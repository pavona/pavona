// Copyright lowRISC contributors (OpenTitan project).
// Licensed under the Apache License, Version 2.0, see LICENSE for details.
// SPDX-License-Identifier: Apache-2.0
//
// HJSON with partition metadata.
//
{
  name:               "otp_ctrl",
  human_name:         "One-Time Programmable Memory Controller",
  one_line_desc:      "Interfaces integrated one-time programmable memory, supports scrambling, integrity and secure wipe",
  one_paragraph_desc: '''
  One-Time Programmable (OTP) Memory Controller provides an open source abstraction interface for software and other hardware components such as Life Cycle Controller and Key Manager to interact with an integrated, closed source, proprietary OTP memory.
  On top of defensive features provided by the proprietary OTP memory to deter side-channel analysis (SCA), fault injection (FI) attacks, and visual and electrical probing, the open source OTP controller features high-level logical security protection such as integrity checks and scrambling, as well as software isolation for when OTP contents are readable and programmable.
  It features multiple individually-lockable logical partitions, periodic / persistent checking of OTP values, and a separate partition and interface for Life Cycle Controller.
  '''
  // Unique comportable IP identifier defined under KNOWN_CIP_IDS in the regtool.
  cip_id:             "16",
  design_spec:        "../doc",
  dv_doc:             "../doc/dv",
  hw_checklist:       "../doc/checklist",
  sw_checklist:       "/sw/device/lib/dif/dif_otp_ctrl",
  revisions: [
    {
      version:            "0.1.0",
      life_stage:         "L1",
      design_stage:       "D2",
      verification_stage: "V2",
      dif_stage:          "S1",
      commit_id:          "127b109e2fab9336e830158abe449a3922544ded",
      notes:              "",
    }
    {
      version:            "1.0.0",
      life_stage:         "L1",
      design_stage:       "D3",
      verification_stage: "V2S",
      dif_stage:          "S2",
      notes:              "",
    }
    {
      version:            "3.0.0",
      life_stage:         "L1",
      design_stage:       "D1",
      verification_stage: "V1",
      dif_stage:          "S2",
      notes:              "",
    }
  ]
  clocking: [
    {clock: "clk_i", reset: "rst_ni", primary: true},
    {clock: "clk_edn_i", reset: "rst_edn_ni"}
  ]
  bus_interfaces: [
    { protocol: "tlul", direction: "device", name: "core" }
  ],

  ///////////////////////////
  // Interrupts and Alerts //
  ///////////////////////////

  interrupt_list: [
    { name: "otp_operation_done",
      desc: "A direct access command or digest calculation operation has completed."
    }
    { name: "otp_error",
      desc: "An error has occurred in the OTP controller. Check the !!ERR_CODE register to get more information."
    }
  ],

  alert_list: [
    { name: "fatal_macro_error",
      desc: "This alert triggers if hardware detects an uncorrectable error during an OTP transaction, for example an uncorrectable ECC error in the OTP array.",
    }
    { name: "fatal_check_error",
      desc: "This alert triggers if any of the background checks fails. This includes the digest checks and concurrent ECC checks in the buffer registers.",
    }
    { name: "fatal_bus_integ_error",
      desc: "This fatal alert is triggered when a fatal TL-UL bus integrity fault is detected."
    }
    { name: "fatal_prim_otp_alert",
      desc: "Fatal alert triggered inside the OTP primitive, including fatal TL-UL bus integrity faults of the test interface."
    }
    { name: "recov_prim_otp_alert",
      desc: "Recoverable alert triggered inside the OTP primitive."
    }
  ],

  ////////////////
  // Parameters //
  ////////////////
  param_list: [
    // Random netlist constants
    { name:      "RndCnstLfsrSeed",
      desc:      "Compile-time random bits for initial LFSR seed",
      type:      "otp_ctrl_top_specific_pkg::lfsr_seed_t"
      randcount: "40",
      randtype:  "data", // randomize randcount databits
    }
    { name:      "RndCnstLfsrPerm",
      desc:      "Compile-time random permutation for LFSR output",
      type:      "otp_ctrl_top_specific_pkg::lfsr_perm_t"
      randcount: "40",
      randtype:  "perm", // random permutation for randcount elements
    }
    { name:      "RndCnstScrmblKeyInit",
      desc:      "Compile-time random permutation for scrambling key/nonce register reset value",
      type:      "otp_ctrl_top_specific_pkg::scrmbl_key_init_t"
      randcount: "256",
      randtype:  "data", // random permutation for randcount elements
    }
    // Scrambling Keys
    { name:      "RndCnstScrmblKey0",
      desc:      "Compile-time scrambling key",
      type:      "otp_ctrl_top_specific_pkg::key_t"
      randcount: "128",
      randtype:  "extdata",
    }
    { name:      "RndCnstScrmblKey1",
      desc:      "Compile-time scrambling key",
      type:      "otp_ctrl_top_specific_pkg::key_t"
      randcount: "128",
      randtype:  "extdata",
    }
    { name:      "RndCnstScrmblKey2",
      desc:      "Compile-time scrambling key",
      type:      "otp_ctrl_top_specific_pkg::key_t"
      randcount: "128",
      randtype:  "extdata",
    }
    { name:      "RndCnstScrmblKey3",
      desc:      "Compile-time scrambling key",
      type:      "otp_ctrl_top_specific_pkg::key_t"
      randcount: "128",
      randtype:  "extdata",
    }
    { name:      "RndCnstDigestConst0",
      desc:      "Compile-time digest const",
      type:      "otp_ctrl_top_specific_pkg::digest_const_t"
      randcount: "128",
      randtype:  "extdata",
    }
    { name:      "RndCnstDigestConst1",
      desc:      "Compile-time digest const",
      type:      "otp_ctrl_top_specific_pkg::digest_const_t"
      randcount: "128",
      randtype:  "extdata",
    }
    { name:      "RndCnstDigestIV0",
      desc:      "Compile-time digest initial vector",
      type:      "otp_ctrl_top_specific_pkg::digest_iv_t"
      randcount: "64",
      randtype:  "extdata",
    }
    { name:      "RndCnstDigestIV1",
      desc:      "Compile-time digest initial vector",
      type:      "otp_ctrl_top_specific_pkg::digest_iv_t"
      randcount: "64",
      randtype:  "extdata",
    }

    { name:      "RndCnstPartInvDefault",
      desc:      "OTP invalid partition default for buffered partitions",
      type:      "logic [163839:0]"
      randcount: "163840",
      randtype:  "extdata",
    }
    // Normal parameters
    { name: "NumSramKeyReqSlots",
      desc: "Number of key slots",
      type: "int",
      default: "4",
      local: "true"
    },
    // Macro parameters
    {
      name: "OtpDepth",
      desc: "Number of native words.",
      default: "10240",
      local: "true"
    },
    {
      name: "OtpWidth",
      desc: "Number of bytes in native words.",
      default: "2",
      local: "true"
    },
    {
      name: "OtpSizeWidth",
      desc: "Number of bits to represent the native words per transaction.",
      default: "2",
      local: "true"
    },
    { name: "OtpByteAddrWidth",
      desc: "Width of the OTP byte address.",
      type: "int",
      default: "15",
      local: "true"
    },
    { name: "NumErrorEntries",
      desc: "Number of error register entries.",
      type: "int",
      default: "27", // partitions + DAI/LCI
      local: "true"
    },
    { name: "NumDaiWords",
      desc: "Number of 32bit words in the DAI.",
      type: "int",
      default: "2",
      local: "true"
    },
    { name: "NumDigestWords",
      desc: "Size of the digest fields in 32bit words.",
      type: "int",
      default: "2",
      local: "true"
    },
    { name: "NumSwCfgWindowWords",
      desc: "Size of the TL-UL window in 32bit words. Note that the effective partition size is smaller than that.",
      type: "int",
      default: "8192",
      local: "true"
    }

    // Memory map Info
    { name: "NumPart",
      desc: "Number of partitions",
      type: "int",
      default: "25",
      local: "true"
    },
    { name: "NumPartUnbuf",
      desc: "Number of unbuffered partitions",
      type: "int",
      default: "17",
      local: "true"
    },
    { name: "NumPartBuf",
      desc: "Number of buffered partitions (including 1 lifecycle partition)",
      type: "int",
      default: "8",
      local: "true"
    },
    { name: "VendorTestOffset",
      desc: "Offset of the VENDOR_TEST partition",
      type: "int",
      default: "0",
      local: "true"
    },
    { name: "VendorTestSize",
      desc: "Size of the VENDOR_TEST partition",
      type: "int",
      default: "72",
      local: "true"
    },
    { name: "ScratchOffset",
      desc: "Offset of SCRATCH",
      type: "int",
      default: "0",
      local: "true"
    },
    { name: "ScratchSize",
      desc: "Size of SCRATCH",
      type: "int",
      default: "56",
      local: "true"
    },
    { name: "VendorTestDigestOffset",
      desc: "Offset of VENDOR_TEST_DIGEST",
      type: "int",
      default: "56",
      local: "true"
    },
    { name: "VendorTestDigestSize",
      desc: "Size of VENDOR_TEST_DIGEST",
      type: "int",
      default: "8",
      local: "true"
    },
    { name: "VendorTestZerOffset",
      desc: "Offset of VENDOR_TEST_ZER",
      type: "int",
      default: "64",
      local: "true"
    },
    { name: "VendorTestZerSize",
      desc: "Size of VENDOR_TEST_ZER",
      type: "int",
      default: "8",
      local: "true"
    },
    { name: "CreatorSwCfgOffset",
      desc: "Offset of the CREATOR_SW_CFG partition",
      type: "int",
      default: "72",
      local: "true"
    },
    { name: "CreatorSwCfgSize",
      desc: "Size of the CREATOR_SW_CFG partition",
      type: "int",
      default: "280",
      local: "true"
    },
    { name: "CreatorSwCfgAstCfgOffset",
      desc: "Offset of CREATOR_SW_CFG_AST_CFG",
      type: "int",
      default: "72",
      local: "true"
    },
    { name: "CreatorSwCfgAstCfgSize",
      desc: "Size of CREATOR_SW_CFG_AST_CFG",
      type: "int",
      default: "124",
      local: "true"
    },
    { name: "CreatorSwCfgAstInitEnOffset",
      desc: "Offset of CREATOR_SW_CFG_AST_INIT_EN",
      type: "int",
      default: "196",
      local: "true"
    },
    { name: "CreatorSwCfgAstInitEnSize",
      desc: "Size of CREATOR_SW_CFG_AST_INIT_EN",
      type: "int",
      default: "4",
      local: "true"
    },
    { name: "CreatorSwCfgAstInitSizeOffset",
      desc: "Offset of CREATOR_SW_CFG_AST_INIT_SIZE",
      type: "int",
      default: "200",
      local: "true"
    },
    { name: "CreatorSwCfgAstInitSizeSize",
      desc: "Size of CREATOR_SW_CFG_AST_INIT_SIZE",
      type: "int",
      default: "4",
      local: "true"
    },
    { name: "CreatorSwCfgSigverifySpxEnOffset",
      desc: "Offset of CREATOR_SW_CFG_SIGVERIFY_SPX_EN",
      type: "int",
      default: "204",
      local: "true"
    },
    { name: "CreatorSwCfgSigverifySpxEnSize",
      desc: "Size of CREATOR_SW_CFG_SIGVERIFY_SPX_EN",
      type: "int",
      default: "4",
      local: "true"
    },
    { name: "CreatorSwCfgRngEnOffset",
      desc: "Offset of CREATOR_SW_CFG_RNG_EN",
      type: "int",
      default: "208",
      local: "true"
    },
    { name: "CreatorSwCfgRngEnSize",
      desc: "Size of CREATOR_SW_CFG_RNG_EN",
      type: "int",
      default: "4",
      local: "true"
    },
    { name: "CreatorSwCfgJitterEnOffset",
      desc: "Offset of CREATOR_SW_CFG_JITTER_EN",
      type: "int",
      default: "212",
      local: "true"
    },
    { name: "CreatorSwCfgJitterEnSize",
      desc: "Size of CREATOR_SW_CFG_JITTER_EN",
      type: "int",
      default: "4",
      local: "true"
    },
    { name: "CreatorSwCfgRetRamResetMaskOffset",
      desc: "Offset of CREATOR_SW_CFG_RET_RAM_RESET_MASK",
      type: "int",
      default: "216",
      local: "true"
    },
    { name: "CreatorSwCfgRetRamResetMaskSize",
      desc: "Size of CREATOR_SW_CFG_RET_RAM_RESET_MASK",
      type: "int",
      default: "4",
      local: "true"
    },
    { name: "CreatorSwCfgManufStateOffset",
      desc: "Offset of CREATOR_SW_CFG_MANUF_STATE",
      type: "int",
      default: "220",
      local: "true"
    },
    { name: "CreatorSwCfgManufStateSize",
      desc: "Size of CREATOR_SW_CFG_MANUF_STATE",
      type: "int",
      default: "4",
      local: "true"
    },
    { name: "CreatorSwCfgRomExecEnOffset",
      desc: "Offset of CREATOR_SW_CFG_ROM_EXEC_EN",
      type: "int",
      default: "224",
      local: "true"
    },
    { name: "CreatorSwCfgRomExecEnSize",
      desc: "Size of CREATOR_SW_CFG_ROM_EXEC_EN",
      type: "int",
      default: "4",
      local: "true"
    },
    { name: "CreatorSwCfgCpuctrlOffset",
      desc: "Offset of CREATOR_SW_CFG_CPUCTRL",
      type: "int",
      default: "228",
      local: "true"
    },
    { name: "CreatorSwCfgCpuctrlSize",
      desc: "Size of CREATOR_SW_CFG_CPUCTRL",
      type: "int",
      default: "4",
      local: "true"
    },
    { name: "CreatorSwCfgMinSecVerRomExtOffset",
      desc: "Offset of CREATOR_SW_CFG_MIN_SEC_VER_ROM_EXT",
      type: "int",
      default: "232",
      local: "true"
    },
    { name: "CreatorSwCfgMinSecVerRomExtSize",
      desc: "Size of CREATOR_SW_CFG_MIN_SEC_VER_ROM_EXT",
      type: "int",
      default: "4",
      local: "true"
    },
    { name: "CreatorSwCfgMinSecVerBl0Offset",
      desc: "Offset of CREATOR_SW_CFG_MIN_SEC_VER_BL0",
      type: "int",
      default: "236",
      local: "true"
    },
    { name: "CreatorSwCfgMinSecVerBl0Size",
      desc: "Size of CREATOR_SW_CFG_MIN_SEC_VER_BL0",
      type: "int",
      default: "4",
      local: "true"
    },
    { name: "CreatorSwCfgDefaultBootDataInProdEnOffset",
      desc: "Offset of CREATOR_SW_CFG_DEFAULT_BOOT_DATA_IN_PROD_EN",
      type: "int",
      default: "240",
      local: "true"
    },
    { name: "CreatorSwCfgDefaultBootDataInProdEnSize",
      desc: "Size of CREATOR_SW_CFG_DEFAULT_BOOT_DATA_IN_PROD_EN",
      type: "int",
      default: "4",
      local: "true"
    },
    { name: "CreatorSwCfgRngRepcntThresholdsOffset",
      desc: "Offset of CREATOR_SW_CFG_RNG_REPCNT_THRESHOLDS",
      type: "int",
      default: "244",
      local: "true"
    },
    { name: "CreatorSwCfgRngRepcntThresholdsSize",
      desc: "Size of CREATOR_SW_CFG_RNG_REPCNT_THRESHOLDS",
      type: "int",
      default: "4",
      local: "true"
    },
    { name: "CreatorSwCfgRngRepcntsThresholdsOffset",
      desc: "Offset of CREATOR_SW_CFG_RNG_REPCNTS_THRESHOLDS",
      type: "int",
      default: "248",
      local: "true"
    },
    { name: "CreatorSwCfgRngRepcntsThresholdsSize",
      desc: "Size of CREATOR_SW_CFG_RNG_REPCNTS_THRESHOLDS",
      type: "int",
      default: "4",
      local: "true"
    },
    { name: "CreatorSwCfgRngAdaptpHiThresholdsOffset",
      desc: "Offset of CREATOR_SW_CFG_RNG_ADAPTP_HI_THRESHOLDS",
      type: "int",
      default: "252",
      local: "true"
    },
    { name: "CreatorSwCfgRngAdaptpHiThresholdsSize",
      desc: "Size of CREATOR_SW_CFG_RNG_ADAPTP_HI_THRESHOLDS",
      type: "int",
      default: "4",
      local: "true"
    },
    { name: "CreatorSwCfgRngAdaptpLoThresholdsOffset",
      desc: "Offset of CREATOR_SW_CFG_RNG_ADAPTP_LO_THRESHOLDS",
      type: "int",
      default: "256",
      local: "true"
    },
    { name: "CreatorSwCfgRngAdaptpLoThresholdsSize",
      desc: "Size of CREATOR_SW_CFG_RNG_ADAPTP_LO_THRESHOLDS",
      type: "int",
      default: "4",
      local: "true"
    },
    { name: "CreatorSwCfgRngBucketThresholdsOffset",
      desc: "Offset of CREATOR_SW_CFG_RNG_BUCKET_THRESHOLDS",
      type: "int",
      default: "260",
      local: "true"
    },
    { name: "CreatorSwCfgRngBucketThresholdsSize",
      desc: "Size of CREATOR_SW_CFG_RNG_BUCKET_THRESHOLDS",
      type: "int",
      default: "4",
      local: "true"
    },
    { name: "CreatorSwCfgRngMarkovHiThresholdsOffset",
      desc: "Offset of CREATOR_SW_CFG_RNG_MARKOV_HI_THRESHOLDS",
      type: "int",
      default: "264",
      local: "true"
    },
    { name: "CreatorSwCfgRngMarkovHiThresholdsSize",
      desc: "Size of CREATOR_SW_CFG_RNG_MARKOV_HI_THRESHOLDS",
      type: "int",
      default: "4",
      local: "true"
    },
    { name: "CreatorSwCfgRngMarkovLoThresholdsOffset",
      desc: "Offset of CREATOR_SW_CFG_RNG_MARKOV_LO_THRESHOLDS",
      type: "int",
      default: "268",
      local: "true"
    },
    { name: "CreatorSwCfgRngMarkovLoThresholdsSize",
      desc: "Size of CREATOR_SW_CFG_RNG_MARKOV_LO_THRESHOLDS",
      type: "int",
      default: "4",
      local: "true"
    },
    { name: "CreatorSwCfgRngExthtHiThresholdsOffset",
      desc: "Offset of CREATOR_SW_CFG_RNG_EXTHT_HI_THRESHOLDS",
      type: "int",
      default: "272",
      local: "true"
    },
    { name: "CreatorSwCfgRngExthtHiThresholdsSize",
      desc: "Size of CREATOR_SW_CFG_RNG_EXTHT_HI_THRESHOLDS",
      type: "int",
      default: "4",
      local: "true"
    },
    { name: "CreatorSwCfgRngExthtLoThresholdsOffset",
      desc: "Offset of CREATOR_SW_CFG_RNG_EXTHT_LO_THRESHOLDS",
      type: "int",
      default: "276",
      local: "true"
    },
    { name: "CreatorSwCfgRngExthtLoThresholdsSize",
      desc: "Size of CREATOR_SW_CFG_RNG_EXTHT_LO_THRESHOLDS",
      type: "int",
      default: "4",
      local: "true"
    },
    { name: "CreatorSwCfgRngAlertThresholdOffset",
      desc: "Offset of CREATOR_SW_CFG_RNG_ALERT_THRESHOLD",
      type: "int",
      default: "280",
      local: "true"
    },
    { name: "CreatorSwCfgRngAlertThresholdSize",
      desc: "Size of CREATOR_SW_CFG_RNG_ALERT_THRESHOLD",
      type: "int",
      default: "4",
      local: "true"
    },
    { name: "CreatorSwCfgRngHealthConfigDigestOffset",
      desc: "Offset of CREATOR_SW_CFG_RNG_HEALTH_CONFIG_DIGEST",
      type: "int",
      default: "284",
      local: "true"
    },
    { name: "CreatorSwCfgRngHealthConfigDigestSize",
      desc: "Size of CREATOR_SW_CFG_RNG_HEALTH_CONFIG_DIGEST",
      type: "int",
      default: "4",
      local: "true"
    },
    { name: "CreatorSwCfgSramKeyRenewAndInitEnOffset",
      desc: "Offset of CREATOR_SW_CFG_SRAM_KEY_RENEW_AND_INIT_EN",
      type: "int",
      default: "288",
      local: "true"
    },
    { name: "CreatorSwCfgSramKeyRenewAndInitEnSize",
      desc: "Size of CREATOR_SW_CFG_SRAM_KEY_RENEW_AND_INIT_EN",
      type: "int",
      default: "4",
      local: "true"
    },
    { name: "CreatorSwCfgImmutableRomExtEnOffset",
      desc: "Offset of CREATOR_SW_CFG_IMMUTABLE_ROM_EXT_EN",
      type: "int",
      default: "292",
      local: "true"
    },
    { name: "CreatorSwCfgImmutableRomExtEnSize",
      desc: "Size of CREATOR_SW_CFG_IMMUTABLE_ROM_EXT_EN",
      type: "int",
      default: "4",
      local: "true"
    },
    { name: "CreatorSwCfgImmutableRomExtStartOffsetOffset",
      desc: "Offset of CREATOR_SW_CFG_IMMUTABLE_ROM_EXT_START_OFFSET",
      type: "int",
      default: "296",
      local: "true"
    },
    { name: "CreatorSwCfgImmutableRomExtStartOffsetSize",
      desc: "Size of CREATOR_SW_CFG_IMMUTABLE_ROM_EXT_START_OFFSET",
      type: "int",
      default: "4",
      local: "true"
    },
    { name: "CreatorSwCfgImmutableRomExtLengthOffset",
      desc: "Offset of CREATOR_SW_CFG_IMMUTABLE_ROM_EXT_LENGTH",
      type: "int",
      default: "300",
      local: "true"
    },
    { name: "CreatorSwCfgImmutableRomExtLengthSize",
      desc: "Size of CREATOR_SW_CFG_IMMUTABLE_ROM_EXT_LENGTH",
      type: "int",
      default: "4",
      local: "true"
    },
    { name: "CreatorSwCfgImmutableRomExtSha256HashOffset",
      desc: "Offset of CREATOR_SW_CFG_IMMUTABLE_ROM_EXT_SHA256_HASH",
      type: "int",
      default: "304",
      local: "true"
    },
    { name: "CreatorSwCfgImmutableRomExtSha256HashSize",
      desc: "Size of CREATOR_SW_CFG_IMMUTABLE_ROM_EXT_SHA256_HASH",
      type: "int",
      default: "32",
      local: "true"
    },
    { name: "CreatorSwCfgDigestOffset",
      desc: "Offset of CREATOR_SW_CFG_DIGEST",
      type: "int",
      default: "336",
      local: "true"
    },
    { name: "CreatorSwCfgDigestSize",
      desc: "Size of CREATOR_SW_CFG_DIGEST",
      type: "int",
      default: "8",
      local: "true"
    },
    { name: "CreatorSwCfgZerOffset",
      desc: "Offset of CREATOR_SW_CFG_ZER",
      type: "int",
      default: "344",
      local: "true"
    },
    { name: "CreatorSwCfgZerSize",
      desc: "Size of CREATOR_SW_CFG_ZER",
      type: "int",
      default: "8",
      local: "true"
    },
    { name: "OwnerSwCfgOffset",
      desc: "Offset of the OWNER_SW_CFG partition",
      type: "int",
      default: "352",
      local: "true"
    },
    { name: "OwnerSwCfgSize",
      desc: "Size of the OWNER_SW_CFG partition",
      type: "int",
      default: "984",
      local: "true"
    },
    { name: "OwnerSwCfgRomErrorReportingOffset",
      desc: "Offset of OWNER_SW_CFG_ROM_ERROR_REPORTING",
      type: "int",
      default: "352",
      local: "true"
    },
    { name: "OwnerSwCfgRomErrorReportingSize",
      desc: "Size of OWNER_SW_CFG_ROM_ERROR_REPORTING",
      type: "int",
      default: "4",
      local: "true"
    },
    { name: "OwnerSwCfgRomAlertClassEnOffset",
      desc: "Offset of OWNER_SW_CFG_ROM_ALERT_CLASS_EN",
      type: "int",
      default: "356",
      local: "true"
    },
    { name: "OwnerSwCfgRomAlertClassEnSize",
      desc: "Size of OWNER_SW_CFG_ROM_ALERT_CLASS_EN",
      type: "int",
      default: "4",
      local: "true"
    },
    { name: "OwnerSwCfgRomAlertEscalationOffset",
      desc: "Offset of OWNER_SW_CFG_ROM_ALERT_ESCALATION",
      type: "int",
      default: "360",
      local: "true"
    },
    { name: "OwnerSwCfgRomAlertEscalationSize",
      desc: "Size of OWNER_SW_CFG_ROM_ALERT_ESCALATION",
      type: "int",
      default: "4",
      local: "true"
    },
    { name: "OwnerSwCfgRomAlertClassificationOffset",
      desc: "Offset of OWNER_SW_CFG_ROM_ALERT_CLASSIFICATION",
      type: "int",
      default: "364",
      local: "true"
    },
    { name: "OwnerSwCfgRomAlertClassificationSize",
      desc: "Size of OWNER_SW_CFG_ROM_ALERT_CLASSIFICATION",
      type: "int",
      default: "788",
      local: "true"
    },
    { name: "OwnerSwCfgRomLocalAlertClassificationOffset",
      desc: "Offset of OWNER_SW_CFG_ROM_LOCAL_ALERT_CLASSIFICATION",
      type: "int",
      default: "1152",
      local: "true"
    },
    { name: "OwnerSwCfgRomLocalAlertClassificationSize",
      desc: "Size of OWNER_SW_CFG_ROM_LOCAL_ALERT_CLASSIFICATION",
      type: "int",
      default: "28",
      local: "true"
    },
    { name: "OwnerSwCfgRomAlertAccumThreshOffset",
      desc: "Offset of OWNER_SW_CFG_ROM_ALERT_ACCUM_THRESH",
      type: "int",
      default: "1180",
      local: "true"
    },
    { name: "OwnerSwCfgRomAlertAccumThreshSize",
      desc: "Size of OWNER_SW_CFG_ROM_ALERT_ACCUM_THRESH",
      type: "int",
      default: "16",
      local: "true"
    },
    { name: "OwnerSwCfgRomAlertTimeoutCyclesOffset",
      desc: "Offset of OWNER_SW_CFG_ROM_ALERT_TIMEOUT_CYCLES",
      type: "int",
      default: "1196",
      local: "true"
    },
    { name: "OwnerSwCfgRomAlertTimeoutCyclesSize",
      desc: "Size of OWNER_SW_CFG_ROM_ALERT_TIMEOUT_CYCLES",
      type: "int",
      default: "16",
      local: "true"
    },
    { name: "OwnerSwCfgRomAlertPhaseCyclesOffset",
      desc: "Offset of OWNER_SW_CFG_ROM_ALERT_PHASE_CYCLES",
      type: "int",
      default: "1212",
      local: "true"
    },
    { name: "OwnerSwCfgRomAlertPhaseCyclesSize",
      desc: "Size of OWNER_SW_CFG_ROM_ALERT_PHASE_CYCLES",
      type: "int",
      default: "64",
      local: "true"
    },
    { name: "OwnerSwCfgRomAlertDigestProdOffset",
      desc: "Offset of OWNER_SW_CFG_ROM_ALERT_DIGEST_PROD",
      type: "int",
      default: "1276",
      local: "true"
    },
    { name: "OwnerSwCfgRomAlertDigestProdSize",
      desc: "Size of OWNER_SW_CFG_ROM_ALERT_DIGEST_PROD",
      type: "int",
      default: "4",
      local: "true"
    },
    { name: "OwnerSwCfgRomAlertDigestProdEndOffset",
      desc: "Offset of OWNER_SW_CFG_ROM_ALERT_DIGEST_PROD_END",
      type: "int",
      default: "1280",
      local: "true"
    },
    { name: "OwnerSwCfgRomAlertDigestProdEndSize",
      desc: "Size of OWNER_SW_CFG_ROM_ALERT_DIGEST_PROD_END",
      type: "int",
      default: "4",
      local: "true"
    },
    { name: "OwnerSwCfgRomAlertDigestDevOffset",
      desc: "Offset of OWNER_SW_CFG_ROM_ALERT_DIGEST_DEV",
      type: "int",
      default: "1284",
      local: "true"
    },
    { name: "OwnerSwCfgRomAlertDigestDevSize",
      desc: "Size of OWNER_SW_CFG_ROM_ALERT_DIGEST_DEV",
      type: "int",
      default: "4",
      local: "true"
    },
    { name: "OwnerSwCfgRomAlertDigestRmaOffset",
      desc: "Offset of OWNER_SW_CFG_ROM_ALERT_DIGEST_RMA",
      type: "int",
      default: "1288",
      local: "true"
    },
    { name: "OwnerSwCfgRomAlertDigestRmaSize",
      desc: "Size of OWNER_SW_CFG_ROM_ALERT_DIGEST_RMA",
      type: "int",
      default: "4",
      local: "true"
    },
    { name: "OwnerSwCfgRomWatchdogBiteThresholdCyclesOffset",
      desc: "Offset of OWNER_SW_CFG_ROM_WATCHDOG_BITE_THRESHOLD_CYCLES",
      type: "int",
      default: "1292",
      local: "true"
    },
    { name: "OwnerSwCfgRomWatchdogBiteThresholdCyclesSize",
      desc: "Size of OWNER_SW_CFG_ROM_WATCHDOG_BITE_THRESHOLD_CYCLES",
      type: "int",
      default: "4",
      local: "true"
    },
    { name: "OwnerSwCfgRomKeymgrOtpMeasEnOffset",
      desc: "Offset of OWNER_SW_CFG_ROM_KEYMGR_OTP_MEAS_EN",
      type: "int",
      default: "1296",
      local: "true"
    },
    { name: "OwnerSwCfgRomKeymgrOtpMeasEnSize",
      desc: "Size of OWNER_SW_CFG_ROM_KEYMGR_OTP_MEAS_EN",
      type: "int",
      default: "4",
      local: "true"
    },
    { name: "OwnerSwCfgManufStateOffset",
      desc: "Offset of OWNER_SW_CFG_MANUF_STATE",
      type: "int",
      default: "1300",
      local: "true"
    },
    { name: "OwnerSwCfgManufStateSize",
      desc: "Size of OWNER_SW_CFG_MANUF_STATE",
      type: "int",
      default: "4",
      local: "true"
    },
    { name: "OwnerSwCfgRomRstmgrInfoEnOffset",
      desc: "Offset of OWNER_SW_CFG_ROM_RSTMGR_INFO_EN",
      type: "int",
      default: "1304",
      local: "true"
    },
    { name: "OwnerSwCfgRomRstmgrInfoEnSize",
      desc: "Size of OWNER_SW_CFG_ROM_RSTMGR_INFO_EN",
      type: "int",
      default: "4",
      local: "true"
    },
    { name: "OwnerSwCfgRomSramReadbackEnOffset",
      desc: "Offset of OWNER_SW_CFG_ROM_SRAM_READBACK_EN",
      type: "int",
      default: "1308",
      local: "true"
    },
    { name: "OwnerSwCfgRomSramReadbackEnSize",
      desc: "Size of OWNER_SW_CFG_ROM_SRAM_READBACK_EN",
      type: "int",
      default: "4",
      local: "true"
    },
    { name: "OwnerSwCfgRomPreserveResetReasonEnOffset",
      desc: "Offset of OWNER_SW_CFG_ROM_PRESERVE_RESET_REASON_EN",
      type: "int",
      default: "1312",
      local: "true"
    },
    { name: "OwnerSwCfgRomPreserveResetReasonEnSize",
      desc: "Size of OWNER_SW_CFG_ROM_PRESERVE_RESET_REASON_EN",
      type: "int",
      default: "4",
      local: "true"
    },
    { name: "OwnerSwCfgRomResetReasonCheckValueOffset",
      desc: "Offset of OWNER_SW_CFG_ROM_RESET_REASON_CHECK_VALUE",
      type: "int",
      default: "1316",
      local: "true"
    },
    { name: "OwnerSwCfgRomResetReasonCheckValueSize",
      desc: "Size of OWNER_SW_CFG_ROM_RESET_REASON_CHECK_VALUE",
      type: "int",
      default: "4",
      local: "true"
    },
    { name: "OwnerSwCfgDigestOffset",
      desc: "Offset of OWNER_SW_CFG_DIGEST",
      type: "int",
      default: "1320",
      local: "true"
    },
    { name: "OwnerSwCfgDigestSize",
      desc: "Size of OWNER_SW_CFG_DIGEST",
      type: "int",
      default: "8",
      local: "true"
    },
    { name: "OwnerSwCfgZerOffset",
      desc: "Offset of OWNER_SW_CFG_ZER",
      type: "int",
      default: "1328",
      local: "true"
    },
    { name: "OwnerSwCfgZerSize",
      desc: "Size of OWNER_SW_CFG_ZER",
      type: "int",
      default: "8",
      local: "true"
    },
    { name: "OwnershipSlotStateOffset",
      desc: "Offset of the OWNERSHIP_SLOT_STATE partition",
      type: "int",
      default: "1336",
      local: "true"
    },
    { name: "OwnershipSlotStateSize",
      desc: "Size of the OWNERSHIP_SLOT_STATE partition",
      type: "int",
      default: "56",
      local: "true"
    },
    { name: "OwnershipSlotStateRotOwnerAuthOffset",
      desc: "Offset of OWNERSHIP_SLOT_STATE_ROT_OWNER_AUTH",
      type: "int",
      default: "1336",
      local: "true"
    },
    { name: "OwnershipSlotStateRotOwnerAuthSize",
      desc: "Size of OWNERSHIP_SLOT_STATE_ROT_OWNER_AUTH",
      type: "int",
      default: "16",
      local: "true"
    },
    { name: "OwnershipSlotStatePlatIntegAuthOffset",
      desc: "Offset of OWNERSHIP_SLOT_STATE_PLAT_INTEG_AUTH",
      type: "int",
      default: "1352",
      local: "true"
    },
    { name: "OwnershipSlotStatePlatIntegAuthSize",
      desc: "Size of OWNERSHIP_SLOT_STATE_PLAT_INTEG_AUTH",
      type: "int",
      default: "16",
      local: "true"
    },
    { name: "OwnershipSlotStatePlatOwnerAuthOffset",
      desc: "Offset of OWNERSHIP_SLOT_STATE_PLAT_OWNER_AUTH",
      type: "int",
      default: "1368",
      local: "true"
    },
    { name: "OwnershipSlotStatePlatOwnerAuthSize",
      desc: "Size of OWNERSHIP_SLOT_STATE_PLAT_OWNER_AUTH",
      type: "int",
      default: "16",
      local: "true"
    },
    { name: "OwnershipSlotStateZerOffset",
      desc: "Offset of OWNERSHIP_SLOT_STATE_ZER",
      type: "int",
      default: "1384",
      local: "true"
    },
    { name: "OwnershipSlotStateZerSize",
      desc: "Size of OWNERSHIP_SLOT_STATE_ZER",
      type: "int",
      default: "8",
      local: "true"
    },
    { name: "RotOwnerAuthSlot0Offset",
      desc: "Offset of the ROT_OWNER_AUTH_SLOT0 partition",
      type: "int",
      default: "1392",
      local: "true"
    },
    { name: "RotOwnerAuthSlot0Size",
      desc: "Size of the ROT_OWNER_AUTH_SLOT0 partition",
      type: "int",
      default: "224",
      local: "true"
    },
    { name: "RotOwnerAuthSlot0FirmwareCodesignKeyTypeOffset",
      desc: "Offset of ROT_OWNER_AUTH_SLOT0_FIRMWARE_CODESIGN_KEY_TYPE",
      type: "int",
      default: "1392",
      local: "true"
    },
    { name: "RotOwnerAuthSlot0FirmwareCodesignKeyTypeSize",
      desc: "Size of ROT_OWNER_AUTH_SLOT0_FIRMWARE_CODESIGN_KEY_TYPE",
      type: "int",
      default: "4",
      local: "true"
    },
    { name: "RotOwnerAuthSlot0FirmwareCodesignEcdsaKeyOffset",
      desc: "Offset of ROT_OWNER_AUTH_SLOT0_FIRMWARE_CODESIGN_ECDSA_KEY",
      type: "int",
      default: "1396",
      local: "true"
    },
    { name: "RotOwnerAuthSlot0FirmwareCodesignEcdsaKeySize",
      desc: "Size of ROT_OWNER_AUTH_SLOT0_FIRMWARE_CODESIGN_ECDSA_KEY",
      type: "int",
      default: "64",
      local: "true"
    },
    { name: "RotOwnerAuthSlot0FirmwareCodesignSpxKeyOffset",
      desc: "Offset of ROT_OWNER_AUTH_SLOT0_FIRMWARE_CODESIGN_SPX_KEY",
      type: "int",
      default: "1460",
      local: "true"
    },
    { name: "RotOwnerAuthSlot0FirmwareCodesignSpxKeySize",
      desc: "Size of ROT_OWNER_AUTH_SLOT0_FIRMWARE_CODESIGN_SPX_KEY",
      type: "int",
      default: "32",
      local: "true"
    },
    { name: "RotOwnerAuthSlot0FirmwareCodesignSpxKeyConfigOffset",
      desc: "Offset of ROT_OWNER_AUTH_SLOT0_FIRMWARE_CODESIGN_SPX_KEY_CONFIG",
      type: "int",
      default: "1492",
      local: "true"
    },
    { name: "RotOwnerAuthSlot0FirmwareCodesignSpxKeyConfigSize",
      desc: "Size of ROT_OWNER_AUTH_SLOT0_FIRMWARE_CODESIGN_SPX_KEY_CONFIG",
      type: "int",
      default: "4",
      local: "true"
    },
    { name: "RotOwnerAuthSlot0Rom1PatchSigverifyEcdsaKeyOffset",
      desc: "Offset of ROT_OWNER_AUTH_SLOT0_ROM1_PATCH_SIGVERIFY_ECDSA_KEY",
      type: "int",
      default: "1496",
      local: "true"
    },
    { name: "RotOwnerAuthSlot0Rom1PatchSigverifyEcdsaKeySize",
      desc: "Size of ROT_OWNER_AUTH_SLOT0_ROM1_PATCH_SIGVERIFY_ECDSA_KEY",
      type: "int",
      default: "64",
      local: "true"
    },
    { name: "RotOwnerAuthSlot0Rom1PatchSigverifySpxKeyOffset",
      desc: "Offset of ROT_OWNER_AUTH_SLOT0_ROM1_PATCH_SIGVERIFY_SPX_KEY",
      type: "int",
      default: "1560",
      local: "true"
    },
    { name: "RotOwnerAuthSlot0Rom1PatchSigverifySpxKeySize",
      desc: "Size of ROT_OWNER_AUTH_SLOT0_ROM1_PATCH_SIGVERIFY_SPX_KEY",
      type: "int",
      default: "32",
      local: "true"
    },
    { name: "RotOwnerAuthSlot0Rom1PatchSpxKeyConfigOffset",
      desc: "Offset of ROT_OWNER_AUTH_SLOT0_ROM1_PATCH_SPX_KEY_CONFIG",
      type: "int",
      default: "1592",
      local: "true"
    },
    { name: "RotOwnerAuthSlot0Rom1PatchSpxKeyConfigSize",
      desc: "Size of ROT_OWNER_AUTH_SLOT0_ROM1_PATCH_SPX_KEY_CONFIG",
      type: "int",
      default: "4",
      local: "true"
    },
    { name: "RotOwnerAuthSlot0DigestOffset",
      desc: "Offset of ROT_OWNER_AUTH_SLOT0_DIGEST",
      type: "int",
      default: "1600",
      local: "true"
    },
    { name: "RotOwnerAuthSlot0DigestSize",
      desc: "Size of ROT_OWNER_AUTH_SLOT0_DIGEST",
      type: "int",
      default: "8",
      local: "true"
    },
    { name: "RotOwnerAuthSlot0ZerOffset",
      desc: "Offset of ROT_OWNER_AUTH_SLOT0_ZER",
      type: "int",
      default: "1608",
      local: "true"
    },
    { name: "RotOwnerAuthSlot0ZerSize",
      desc: "Size of ROT_OWNER_AUTH_SLOT0_ZER",
      type: "int",
      default: "8",
      local: "true"
    },
    { name: "RotOwnerAuthSlot1Offset",
      desc: "Offset of the ROT_OWNER_AUTH_SLOT1 partition",
      type: "int",
      default: "1616",
      local: "true"
    },
    { name: "RotOwnerAuthSlot1Size",
      desc: "Size of the ROT_OWNER_AUTH_SLOT1 partition",
      type: "int",
      default: "224",
      local: "true"
    },
    { name: "RotOwnerAuthSlot1FirmwareCodesignKeyTypeOffset",
      desc: "Offset of ROT_OWNER_AUTH_SLOT1_FIRMWARE_CODESIGN_KEY_TYPE",
      type: "int",
      default: "1616",
      local: "true"
    },
    { name: "RotOwnerAuthSlot1FirmwareCodesignKeyTypeSize",
      desc: "Size of ROT_OWNER_AUTH_SLOT1_FIRMWARE_CODESIGN_KEY_TYPE",
      type: "int",
      default: "4",
      local: "true"
    },
    { name: "RotOwnerAuthSlot1FirmwareCodesignEcdsaKeyOffset",
      desc: "Offset of ROT_OWNER_AUTH_SLOT1_FIRMWARE_CODESIGN_ECDSA_KEY",
      type: "int",
      default: "1620",
      local: "true"
    },
    { name: "RotOwnerAuthSlot1FirmwareCodesignEcdsaKeySize",
      desc: "Size of ROT_OWNER_AUTH_SLOT1_FIRMWARE_CODESIGN_ECDSA_KEY",
      type: "int",
      default: "64",
      local: "true"
    },
    { name: "RotOwnerAuthSlot1FirmwareCodesignSpxKeyOffset",
      desc: "Offset of ROT_OWNER_AUTH_SLOT1_FIRMWARE_CODESIGN_SPX_KEY",
      type: "int",
      default: "1684",
      local: "true"
    },
    { name: "RotOwnerAuthSlot1FirmwareCodesignSpxKeySize",
      desc: "Size of ROT_OWNER_AUTH_SLOT1_FIRMWARE_CODESIGN_SPX_KEY",
      type: "int",
      default: "32",
      local: "true"
    },
    { name: "RotOwnerAuthSlot1FirmwareCodesignSpxKeyConfigOffset",
      desc: "Offset of ROT_OWNER_AUTH_SLOT1_FIRMWARE_CODESIGN_SPX_KEY_CONFIG",
      type: "int",
      default: "1716",
      local: "true"
    },
    { name: "RotOwnerAuthSlot1FirmwareCodesignSpxKeyConfigSize",
      desc: "Size of ROT_OWNER_AUTH_SLOT1_FIRMWARE_CODESIGN_SPX_KEY_CONFIG",
      type: "int",
      default: "4",
      local: "true"
    },
    { name: "RotOwnerAuthSlot1Rom1PatchSigverifyEcdsaKeyOffset",
      desc: "Offset of ROT_OWNER_AUTH_SLOT1_ROM1_PATCH_SIGVERIFY_ECDSA_KEY",
      type: "int",
      default: "1720",
      local: "true"
    },
    { name: "RotOwnerAuthSlot1Rom1PatchSigverifyEcdsaKeySize",
      desc: "Size of ROT_OWNER_AUTH_SLOT1_ROM1_PATCH_SIGVERIFY_ECDSA_KEY",
      type: "int",
      default: "64",
      local: "true"
    },
    { name: "RotOwnerAuthSlot1Rom1PatchSigverifySpxKeyOffset",
      desc: "Offset of ROT_OWNER_AUTH_SLOT1_ROM1_PATCH_SIGVERIFY_SPX_KEY",
      type: "int",
      default: "1784",
      local: "true"
    },
    { name: "RotOwnerAuthSlot1Rom1PatchSigverifySpxKeySize",
      desc: "Size of ROT_OWNER_AUTH_SLOT1_ROM1_PATCH_SIGVERIFY_SPX_KEY",
      type: "int",
      default: "32",
      local: "true"
    },
    { name: "RotOwnerAuthSlot1Rom1PatchSpxKeyConfigOffset",
      desc: "Offset of ROT_OWNER_AUTH_SLOT1_ROM1_PATCH_SPX_KEY_CONFIG",
      type: "int",
      default: "1816",
      local: "true"
    },
    { name: "RotOwnerAuthSlot1Rom1PatchSpxKeyConfigSize",
      desc: "Size of ROT_OWNER_AUTH_SLOT1_ROM1_PATCH_SPX_KEY_CONFIG",
      type: "int",
      default: "4",
      local: "true"
    },
    { name: "RotOwnerAuthSlot1DigestOffset",
      desc: "Offset of ROT_OWNER_AUTH_SLOT1_DIGEST",
      type: "int",
      default: "1824",
      local: "true"
    },
    { name: "RotOwnerAuthSlot1DigestSize",
      desc: "Size of ROT_OWNER_AUTH_SLOT1_DIGEST",
      type: "int",
      default: "8",
      local: "true"
    },
    { name: "RotOwnerAuthSlot1ZerOffset",
      desc: "Offset of ROT_OWNER_AUTH_SLOT1_ZER",
      type: "int",
      default: "1832",
      local: "true"
    },
    { name: "RotOwnerAuthSlot1ZerSize",
      desc: "Size of ROT_OWNER_AUTH_SLOT1_ZER",
      type: "int",
      default: "8",
      local: "true"
    },
    { name: "RotOwnerAuthSlot2Offset",
      desc: "Offset of the ROT_OWNER_AUTH_SLOT2 partition",
      type: "int",
      default: "1840",
      local: "true"
    },
    { name: "RotOwnerAuthSlot2Size",
      desc: "Size of the ROT_OWNER_AUTH_SLOT2 partition",
      type: "int",
      default: "224",
      local: "true"
    },
    { name: "RotOwnerAuthSlot2FirmwareCodesignKeyTypeOffset",
      desc: "Offset of ROT_OWNER_AUTH_SLOT2_FIRMWARE_CODESIGN_KEY_TYPE",
      type: "int",
      default: "1840",
      local: "true"
    },
    { name: "RotOwnerAuthSlot2FirmwareCodesignKeyTypeSize",
      desc: "Size of ROT_OWNER_AUTH_SLOT2_FIRMWARE_CODESIGN_KEY_TYPE",
      type: "int",
      default: "4",
      local: "true"
    },
    { name: "RotOwnerAuthSlot2FirmwareCodesignEcdsaKeyOffset",
      desc: "Offset of ROT_OWNER_AUTH_SLOT2_FIRMWARE_CODESIGN_ECDSA_KEY",
      type: "int",
      default: "1844",
      local: "true"
    },
    { name: "RotOwnerAuthSlot2FirmwareCodesignEcdsaKeySize",
      desc: "Size of ROT_OWNER_AUTH_SLOT2_FIRMWARE_CODESIGN_ECDSA_KEY",
      type: "int",
      default: "64",
      local: "true"
    },
    { name: "RotOwnerAuthSlot2FirmwareCodesignSpxKeyOffset",
      desc: "Offset of ROT_OWNER_AUTH_SLOT2_FIRMWARE_CODESIGN_SPX_KEY",
      type: "int",
      default: "1908",
      local: "true"
    },
    { name: "RotOwnerAuthSlot2FirmwareCodesignSpxKeySize",
      desc: "Size of ROT_OWNER_AUTH_SLOT2_FIRMWARE_CODESIGN_SPX_KEY",
      type: "int",
      default: "32",
      local: "true"
    },
    { name: "RotOwnerAuthSlot2FirmwareCodesignSpxKeyConfigOffset",
      desc: "Offset of ROT_OWNER_AUTH_SLOT2_FIRMWARE_CODESIGN_SPX_KEY_CONFIG",
      type: "int",
      default: "1940",
      local: "true"
    },
    { name: "RotOwnerAuthSlot2FirmwareCodesignSpxKeyConfigSize",
      desc: "Size of ROT_OWNER_AUTH_SLOT2_FIRMWARE_CODESIGN_SPX_KEY_CONFIG",
      type: "int",
      default: "4",
      local: "true"
    },
    { name: "RotOwnerAuthSlot2Rom1PatchSigverifyEcdsaKeyOffset",
      desc: "Offset of ROT_OWNER_AUTH_SLOT2_ROM1_PATCH_SIGVERIFY_ECDSA_KEY",
      type: "int",
      default: "1944",
      local: "true"
    },
    { name: "RotOwnerAuthSlot2Rom1PatchSigverifyEcdsaKeySize",
      desc: "Size of ROT_OWNER_AUTH_SLOT2_ROM1_PATCH_SIGVERIFY_ECDSA_KEY",
      type: "int",
      default: "64",
      local: "true"
    },
    { name: "RotOwnerAuthSlot2Rom1PatchSigverifySpxKeyOffset",
      desc: "Offset of ROT_OWNER_AUTH_SLOT2_ROM1_PATCH_SIGVERIFY_SPX_KEY",
      type: "int",
      default: "2008",
      local: "true"
    },
    { name: "RotOwnerAuthSlot2Rom1PatchSigverifySpxKeySize",
      desc: "Size of ROT_OWNER_AUTH_SLOT2_ROM1_PATCH_SIGVERIFY_SPX_KEY",
      type: "int",
      default: "32",
      local: "true"
    },
    { name: "RotOwnerAuthSlot2Rom1PatchSpxKeyConfigOffset",
      desc: "Offset of ROT_OWNER_AUTH_SLOT2_ROM1_PATCH_SPX_KEY_CONFIG",
      type: "int",
      default: "2040",
      local: "true"
    },
    { name: "RotOwnerAuthSlot2Rom1PatchSpxKeyConfigSize",
      desc: "Size of ROT_OWNER_AUTH_SLOT2_ROM1_PATCH_SPX_KEY_CONFIG",
      type: "int",
      default: "4",
      local: "true"
    },
    { name: "RotOwnerAuthSlot2DigestOffset",
      desc: "Offset of ROT_OWNER_AUTH_SLOT2_DIGEST",
      type: "int",
      default: "2048",
      local: "true"
    },
    { name: "RotOwnerAuthSlot2DigestSize",
      desc: "Size of ROT_OWNER_AUTH_SLOT2_DIGEST",
      type: "int",
      default: "8",
      local: "true"
    },
    { name: "RotOwnerAuthSlot2ZerOffset",
      desc: "Offset of ROT_OWNER_AUTH_SLOT2_ZER",
      type: "int",
      default: "2056",
      local: "true"
    },
    { name: "RotOwnerAuthSlot2ZerSize",
      desc: "Size of ROT_OWNER_AUTH_SLOT2_ZER",
      type: "int",
      default: "8",
      local: "true"
    },
    { name: "RotOwnerAuthSlot3Offset",
      desc: "Offset of the ROT_OWNER_AUTH_SLOT3 partition",
      type: "int",
      default: "2064",
      local: "true"
    },
    { name: "RotOwnerAuthSlot3Size",
      desc: "Size of the ROT_OWNER_AUTH_SLOT3 partition",
      type: "int",
      default: "224",
      local: "true"
    },
    { name: "RotOwnerAuthSlot3FirmwareCodesignKeyTypeOffset",
      desc: "Offset of ROT_OWNER_AUTH_SLOT3_FIRMWARE_CODESIGN_KEY_TYPE",
      type: "int",
      default: "2064",
      local: "true"
    },
    { name: "RotOwnerAuthSlot3FirmwareCodesignKeyTypeSize",
      desc: "Size of ROT_OWNER_AUTH_SLOT3_FIRMWARE_CODESIGN_KEY_TYPE",
      type: "int",
      default: "4",
      local: "true"
    },
    { name: "RotOwnerAuthSlot3FirmwareCodesignEcdsaKeyOffset",
      desc: "Offset of ROT_OWNER_AUTH_SLOT3_FIRMWARE_CODESIGN_ECDSA_KEY",
      type: "int",
      default: "2068",
      local: "true"
    },
    { name: "RotOwnerAuthSlot3FirmwareCodesignEcdsaKeySize",
      desc: "Size of ROT_OWNER_AUTH_SLOT3_FIRMWARE_CODESIGN_ECDSA_KEY",
      type: "int",
      default: "64",
      local: "true"
    },
    { name: "RotOwnerAuthSlot3FirmwareCodesignSpxKeyOffset",
      desc: "Offset of ROT_OWNER_AUTH_SLOT3_FIRMWARE_CODESIGN_SPX_KEY",
      type: "int",
      default: "2132",
      local: "true"
    },
    { name: "RotOwnerAuthSlot3FirmwareCodesignSpxKeySize",
      desc: "Size of ROT_OWNER_AUTH_SLOT3_FIRMWARE_CODESIGN_SPX_KEY",
      type: "int",
      default: "32",
      local: "true"
    },
    { name: "RotOwnerAuthSlot3FirmwareCodesignSpxKeyConfigOffset",
      desc: "Offset of ROT_OWNER_AUTH_SLOT3_FIRMWARE_CODESIGN_SPX_KEY_CONFIG",
      type: "int",
      default: "2164",
      local: "true"
    },
    { name: "RotOwnerAuthSlot3FirmwareCodesignSpxKeyConfigSize",
      desc: "Size of ROT_OWNER_AUTH_SLOT3_FIRMWARE_CODESIGN_SPX_KEY_CONFIG",
      type: "int",
      default: "4",
      local: "true"
    },
    { name: "RotOwnerAuthSlot3Rom1PatchSigverifyEcdsaKeyOffset",
      desc: "Offset of ROT_OWNER_AUTH_SLOT3_ROM1_PATCH_SIGVERIFY_ECDSA_KEY",
      type: "int",
      default: "2168",
      local: "true"
    },
    { name: "RotOwnerAuthSlot3Rom1PatchSigverifyEcdsaKeySize",
      desc: "Size of ROT_OWNER_AUTH_SLOT3_ROM1_PATCH_SIGVERIFY_ECDSA_KEY",
      type: "int",
      default: "64",
      local: "true"
    },
    { name: "RotOwnerAuthSlot3Rom1PatchSigverifySpxKeyOffset",
      desc: "Offset of ROT_OWNER_AUTH_SLOT3_ROM1_PATCH_SIGVERIFY_SPX_KEY",
      type: "int",
      default: "2232",
      local: "true"
    },
    { name: "RotOwnerAuthSlot3Rom1PatchSigverifySpxKeySize",
      desc: "Size of ROT_OWNER_AUTH_SLOT3_ROM1_PATCH_SIGVERIFY_SPX_KEY",
      type: "int",
      default: "32",
      local: "true"
    },
    { name: "RotOwnerAuthSlot3Rom1PatchSpxKeyConfigOffset",
      desc: "Offset of ROT_OWNER_AUTH_SLOT3_ROM1_PATCH_SPX_KEY_CONFIG",
      type: "int",
      default: "2264",
      local: "true"
    },
    { name: "RotOwnerAuthSlot3Rom1PatchSpxKeyConfigSize",
      desc: "Size of ROT_OWNER_AUTH_SLOT3_ROM1_PATCH_SPX_KEY_CONFIG",
      type: "int",
      default: "4",
      local: "true"
    },
    { name: "RotOwnerAuthSlot3DigestOffset",
      desc: "Offset of ROT_OWNER_AUTH_SLOT3_DIGEST",
      type: "int",
      default: "2272",
      local: "true"
    },
    { name: "RotOwnerAuthSlot3DigestSize",
      desc: "Size of ROT_OWNER_AUTH_SLOT3_DIGEST",
      type: "int",
      default: "8",
      local: "true"
    },
    { name: "RotOwnerAuthSlot3ZerOffset",
      desc: "Offset of ROT_OWNER_AUTH_SLOT3_ZER",
      type: "int",
      default: "2280",
      local: "true"
    },
    { name: "RotOwnerAuthSlot3ZerSize",
      desc: "Size of ROT_OWNER_AUTH_SLOT3_ZER",
      type: "int",
      default: "8",
      local: "true"
    },
    { name: "RotOwnerAuthSlot0StateOffset",
      desc: "Offset of the ROT_OWNER_AUTH_SLOT0_STATE partition",
      type: "int",
      default: "2288",
      local: "true"
    },
    { name: "RotOwnerAuthSlot0StateSize",
      desc: "Size of the ROT_OWNER_AUTH_SLOT0_STATE partition",
      type: "int",
      default: "24",
      local: "true"
    },
    { name: "RotOwnerAuthSlot0StateFirmwareCodesignEcdsaKeyStateOffset",
      desc: "Offset of ROT_OWNER_AUTH_SLOT0_STATE_FIRMWARE_CODESIGN_ECDSA_KEY_STATE",
      type: "int",
      default: "2288",
      local: "true"
    },
    { name: "RotOwnerAuthSlot0StateFirmwareCodesignEcdsaKeyStateSize",
      desc: "Size of ROT_OWNER_AUTH_SLOT0_STATE_FIRMWARE_CODESIGN_ECDSA_KEY_STATE",
      type: "int",
      default: "4",
      local: "true"
    },
    { name: "RotOwnerAuthSlot0StateFirmwareCodesignSpxKeyStateOffset",
      desc: "Offset of ROT_OWNER_AUTH_SLOT0_STATE_FIRMWARE_CODESIGN_SPX_KEY_STATE",
      type: "int",
      default: "2292",
      local: "true"
    },
    { name: "RotOwnerAuthSlot0StateFirmwareCodesignSpxKeyStateSize",
      desc: "Size of ROT_OWNER_AUTH_SLOT0_STATE_FIRMWARE_CODESIGN_SPX_KEY_STATE",
      type: "int",
      default: "4",
      local: "true"
    },
    { name: "RotOwnerAuthSlot0StateRom1PatchEcdsaKeyStateOffset",
      desc: "Offset of ROT_OWNER_AUTH_SLOT0_STATE_ROM1_PATCH_ECDSA_KEY_STATE",
      type: "int",
      default: "2296",
      local: "true"
    },
    { name: "RotOwnerAuthSlot0StateRom1PatchEcdsaKeyStateSize",
      desc: "Size of ROT_OWNER_AUTH_SLOT0_STATE_ROM1_PATCH_ECDSA_KEY_STATE",
      type: "int",
      default: "4",
      local: "true"
    },
    { name: "RotOwnerAuthSlot0StateRom1PatchSpxKeyStateOffset",
      desc: "Offset of ROT_OWNER_AUTH_SLOT0_STATE_ROM1_PATCH_SPX_KEY_STATE",
      type: "int",
      default: "2300",
      local: "true"
    },
    { name: "RotOwnerAuthSlot0StateRom1PatchSpxKeyStateSize",
      desc: "Size of ROT_OWNER_AUTH_SLOT0_STATE_ROM1_PATCH_SPX_KEY_STATE",
      type: "int",
      default: "4",
      local: "true"
    },
    { name: "RotOwnerAuthSlot0StateDigestOffset",
      desc: "Offset of ROT_OWNER_AUTH_SLOT0_STATE_DIGEST",
      type: "int",
      default: "2304",
      local: "true"
    },
    { name: "RotOwnerAuthSlot0StateDigestSize",
      desc: "Size of ROT_OWNER_AUTH_SLOT0_STATE_DIGEST",
      type: "int",
      default: "8",
      local: "true"
    },
    { name: "RotOwnerAuthSlot1StateOffset",
      desc: "Offset of the ROT_OWNER_AUTH_SLOT1_STATE partition",
      type: "int",
      default: "2312",
      local: "true"
    },
    { name: "RotOwnerAuthSlot1StateSize",
      desc: "Size of the ROT_OWNER_AUTH_SLOT1_STATE partition",
      type: "int",
      default: "24",
      local: "true"
    },
    { name: "RotOwnerAuthSlot1StateFirmwareCodesignEcdsaKeyStateOffset",
      desc: "Offset of ROT_OWNER_AUTH_SLOT1_STATE_FIRMWARE_CODESIGN_ECDSA_KEY_STATE",
      type: "int",
      default: "2312",
      local: "true"
    },
    { name: "RotOwnerAuthSlot1StateFirmwareCodesignEcdsaKeyStateSize",
      desc: "Size of ROT_OWNER_AUTH_SLOT1_STATE_FIRMWARE_CODESIGN_ECDSA_KEY_STATE",
      type: "int",
      default: "4",
      local: "true"
    },
    { name: "RotOwnerAuthSlot1StateFirmwareCodesignSpxKeyStateOffset",
      desc: "Offset of ROT_OWNER_AUTH_SLOT1_STATE_FIRMWARE_CODESIGN_SPX_KEY_STATE",
      type: "int",
      default: "2316",
      local: "true"
    },
    { name: "RotOwnerAuthSlot1StateFirmwareCodesignSpxKeyStateSize",
      desc: "Size of ROT_OWNER_AUTH_SLOT1_STATE_FIRMWARE_CODESIGN_SPX_KEY_STATE",
      type: "int",
      default: "4",
      local: "true"
    },
    { name: "RotOwnerAuthSlot1StateRom1PatchEcdsaKeyStateOffset",
      desc: "Offset of ROT_OWNER_AUTH_SLOT1_STATE_ROM1_PATCH_ECDSA_KEY_STATE",
      type: "int",
      default: "2320",
      local: "true"
    },
    { name: "RotOwnerAuthSlot1StateRom1PatchEcdsaKeyStateSize",
      desc: "Size of ROT_OWNER_AUTH_SLOT1_STATE_ROM1_PATCH_ECDSA_KEY_STATE",
      type: "int",
      default: "4",
      local: "true"
    },
    { name: "RotOwnerAuthSlot1StateRom1PatchSpxKeyStateOffset",
      desc: "Offset of ROT_OWNER_AUTH_SLOT1_STATE_ROM1_PATCH_SPX_KEY_STATE",
      type: "int",
      default: "2324",
      local: "true"
    },
    { name: "RotOwnerAuthSlot1StateRom1PatchSpxKeyStateSize",
      desc: "Size of ROT_OWNER_AUTH_SLOT1_STATE_ROM1_PATCH_SPX_KEY_STATE",
      type: "int",
      default: "4",
      local: "true"
    },
    { name: "RotOwnerAuthSlot1StateDigestOffset",
      desc: "Offset of ROT_OWNER_AUTH_SLOT1_STATE_DIGEST",
      type: "int",
      default: "2328",
      local: "true"
    },
    { name: "RotOwnerAuthSlot1StateDigestSize",
      desc: "Size of ROT_OWNER_AUTH_SLOT1_STATE_DIGEST",
      type: "int",
      default: "8",
      local: "true"
    },
    { name: "RotOwnerAuthSlot2StateOffset",
      desc: "Offset of the ROT_OWNER_AUTH_SLOT2_STATE partition",
      type: "int",
      default: "2336",
      local: "true"
    },
    { name: "RotOwnerAuthSlot2StateSize",
      desc: "Size of the ROT_OWNER_AUTH_SLOT2_STATE partition",
      type: "int",
      default: "24",
      local: "true"
    },
    { name: "RotOwnerAuthSlot2StateFirmwareCodesignEcdsaKeyStateOffset",
      desc: "Offset of ROT_OWNER_AUTH_SLOT2_STATE_FIRMWARE_CODESIGN_ECDSA_KEY_STATE",
      type: "int",
      default: "2336",
      local: "true"
    },
    { name: "RotOwnerAuthSlot2StateFirmwareCodesignEcdsaKeyStateSize",
      desc: "Size of ROT_OWNER_AUTH_SLOT2_STATE_FIRMWARE_CODESIGN_ECDSA_KEY_STATE",
      type: "int",
      default: "4",
      local: "true"
    },
    { name: "RotOwnerAuthSlot2StateFirmwareCodesignSpxKeyStateOffset",
      desc: "Offset of ROT_OWNER_AUTH_SLOT2_STATE_FIRMWARE_CODESIGN_SPX_KEY_STATE",
      type: "int",
      default: "2340",
      local: "true"
    },
    { name: "RotOwnerAuthSlot2StateFirmwareCodesignSpxKeyStateSize",
      desc: "Size of ROT_OWNER_AUTH_SLOT2_STATE_FIRMWARE_CODESIGN_SPX_KEY_STATE",
      type: "int",
      default: "4",
      local: "true"
    },
    { name: "RotOwnerAuthSlot2StateRom1PatchEcdsaKeyStateOffset",
      desc: "Offset of ROT_OWNER_AUTH_SLOT2_STATE_ROM1_PATCH_ECDSA_KEY_STATE",
      type: "int",
      default: "2344",
      local: "true"
    },
    { name: "RotOwnerAuthSlot2StateRom1PatchEcdsaKeyStateSize",
      desc: "Size of ROT_OWNER_AUTH_SLOT2_STATE_ROM1_PATCH_ECDSA_KEY_STATE",
      type: "int",
      default: "4",
      local: "true"
    },
    { name: "RotOwnerAuthSlot2StateRom1PatchSpxKeyStateOffset",
      desc: "Offset of ROT_OWNER_AUTH_SLOT2_STATE_ROM1_PATCH_SPX_KEY_STATE",
      type: "int",
      default: "2348",
      local: "true"
    },
    { name: "RotOwnerAuthSlot2StateRom1PatchSpxKeyStateSize",
      desc: "Size of ROT_OWNER_AUTH_SLOT2_STATE_ROM1_PATCH_SPX_KEY_STATE",
      type: "int",
      default: "4",
      local: "true"
    },
    { name: "RotOwnerAuthSlot2StateDigestOffset",
      desc: "Offset of ROT_OWNER_AUTH_SLOT2_STATE_DIGEST",
      type: "int",
      default: "2352",
      local: "true"
    },
    { name: "RotOwnerAuthSlot2StateDigestSize",
      desc: "Size of ROT_OWNER_AUTH_SLOT2_STATE_DIGEST",
      type: "int",
      default: "8",
      local: "true"
    },
    { name: "RotOwnerAuthSlot3StateOffset",
      desc: "Offset of the ROT_OWNER_AUTH_SLOT3_STATE partition",
      type: "int",
      default: "2360",
      local: "true"
    },
    { name: "RotOwnerAuthSlot3StateSize",
      desc: "Size of the ROT_OWNER_AUTH_SLOT3_STATE partition",
      type: "int",
      default: "24",
      local: "true"
    },
    { name: "RotOwnerAuthSlot3StateFirmwareCodesignEcdsaKeyStateOffset",
      desc: "Offset of ROT_OWNER_AUTH_SLOT3_STATE_FIRMWARE_CODESIGN_ECDSA_KEY_STATE",
      type: "int",
      default: "2360",
      local: "true"
    },
    { name: "RotOwnerAuthSlot3StateFirmwareCodesignEcdsaKeyStateSize",
      desc: "Size of ROT_OWNER_AUTH_SLOT3_STATE_FIRMWARE_CODESIGN_ECDSA_KEY_STATE",
      type: "int",
      default: "4",
      local: "true"
    },
    { name: "RotOwnerAuthSlot3StateFirmwareCodesignSpxKeyStateOffset",
      desc: "Offset of ROT_OWNER_AUTH_SLOT3_STATE_FIRMWARE_CODESIGN_SPX_KEY_STATE",
      type: "int",
      default: "2364",
      local: "true"
    },
    { name: "RotOwnerAuthSlot3StateFirmwareCodesignSpxKeyStateSize",
      desc: "Size of ROT_OWNER_AUTH_SLOT3_STATE_FIRMWARE_CODESIGN_SPX_KEY_STATE",
      type: "int",
      default: "4",
      local: "true"
    },
    { name: "RotOwnerAuthSlot3StateRom1PatchEcdsaKeyStateOffset",
      desc: "Offset of ROT_OWNER_AUTH_SLOT3_STATE_ROM1_PATCH_ECDSA_KEY_STATE",
      type: "int",
      default: "2368",
      local: "true"
    },
    { name: "RotOwnerAuthSlot3StateRom1PatchEcdsaKeyStateSize",
      desc: "Size of ROT_OWNER_AUTH_SLOT3_STATE_ROM1_PATCH_ECDSA_KEY_STATE",
      type: "int",
      default: "4",
      local: "true"
    },
    { name: "RotOwnerAuthSlot3StateRom1PatchSpxKeyStateOffset",
      desc: "Offset of ROT_OWNER_AUTH_SLOT3_STATE_ROM1_PATCH_SPX_KEY_STATE",
      type: "int",
      default: "2372",
      local: "true"
    },
    { name: "RotOwnerAuthSlot3StateRom1PatchSpxKeyStateSize",
      desc: "Size of ROT_OWNER_AUTH_SLOT3_STATE_ROM1_PATCH_SPX_KEY_STATE",
      type: "int",
      default: "4",
      local: "true"
    },
    { name: "RotOwnerAuthSlot3StateDigestOffset",
      desc: "Offset of ROT_OWNER_AUTH_SLOT3_STATE_DIGEST",
      type: "int",
      default: "2376",
      local: "true"
    },
    { name: "RotOwnerAuthSlot3StateDigestSize",
      desc: "Size of ROT_OWNER_AUTH_SLOT3_STATE_DIGEST",
      type: "int",
      default: "8",
      local: "true"
    },
    { name: "ExtNvmOffset",
      desc: "Offset of the EXT_NVM partition",
      type: "int",
      default: "2384",
      local: "true"
    },
    { name: "ExtNvmSize",
      desc: "Size of the EXT_NVM partition",
      type: "int",
      default: "1032",
      local: "true"
    },
    { name: "ExtNvmAntireplayFreshnessCntOffset",
      desc: "Offset of EXT_NVM_ANTIREPLAY_FRESHNESS_CNT",
      type: "int",
      default: "2384",
      local: "true"
    },
    { name: "ExtNvmAntireplayFreshnessCntSize",
      desc: "Size of EXT_NVM_ANTIREPLAY_FRESHNESS_CNT",
      type: "int",
      default: "1024",
      local: "true"
    },
    { name: "ExtNvmZerOffset",
      desc: "Offset of EXT_NVM_ZER",
      type: "int",
      default: "3408",
      local: "true"
    },
    { name: "ExtNvmZerSize",
      desc: "Size of EXT_NVM_ZER",
      type: "int",
      default: "8",
      local: "true"
    },
    { name: "RomPatchOffset",
      desc: "Offset of the ROM_PATCH partition",
      type: "int",
      default: "3416",
      local: "true"
    },
    { name: "RomPatchSize",
      desc: "Size of the ROM_PATCH partition",
      type: "int",
      default: "8208",
      local: "true"
    },
    { name: "RomPatchDataOffset",
      desc: "Offset of ROM_PATCH_DATA",
      type: "int",
      default: "3416",
      local: "true"
    },
    { name: "RomPatchDataSize",
      desc: "Size of ROM_PATCH_DATA",
      type: "int",
      default: "8192",
      local: "true"
    },
    { name: "RomPatchDigestOffset",
      desc: "Offset of ROM_PATCH_DIGEST",
      type: "int",
      default: "11608",
      local: "true"
    },
    { name: "RomPatchDigestSize",
      desc: "Size of ROM_PATCH_DIGEST",
      type: "int",
      default: "8",
      local: "true"
    },
    { name: "RomPatchZerOffset",
      desc: "Offset of ROM_PATCH_ZER",
      type: "int",
      default: "11616",
      local: "true"
    },
    { name: "RomPatchZerSize",
      desc: "Size of ROM_PATCH_ZER",
      type: "int",
      default: "8",
      local: "true"
    },
    { name: "SocFusesCpOffset",
      desc: "Offset of the SOC_FUSES_CP partition",
      type: "int",
      default: "11624",
      local: "true"
    },
    { name: "SocFusesCpSize",
      desc: "Size of the SOC_FUSES_CP partition",
      type: "int",
      default: "392",
      local: "true"
    },
    { name: "SocFusesCp1DataOffset",
      desc: "Offset of SOC_FUSES_CP1_DATA",
      type: "int",
      default: "11624",
      local: "true"
    },
    { name: "SocFusesCp1DataSize",
      desc: "Size of SOC_FUSES_CP1_DATA",
      type: "int",
      default: "256",
      local: "true"
    },
    { name: "SocFusesCp2DataOffset",
      desc: "Offset of SOC_FUSES_CP2_DATA",
      type: "int",
      default: "11880",
      local: "true"
    },
    { name: "SocFusesCp2DataSize",
      desc: "Size of SOC_FUSES_CP2_DATA",
      type: "int",
      default: "128",
      local: "true"
    },
    { name: "SocFusesCpDigestOffset",
      desc: "Offset of SOC_FUSES_CP_DIGEST",
      type: "int",
      default: "12008",
      local: "true"
    },
    { name: "SocFusesCpDigestSize",
      desc: "Size of SOC_FUSES_CP_DIGEST",
      type: "int",
      default: "8",
      local: "true"
    },
    { name: "SocFusesFtOffset",
      desc: "Offset of the SOC_FUSES_FT partition",
      type: "int",
      default: "12016",
      local: "true"
    },
    { name: "SocFusesFtSize",
      desc: "Size of the SOC_FUSES_FT partition",
      type: "int",
      default: "4232",
      local: "true"
    },
    { name: "SocFusesFt1DataOffset",
      desc: "Offset of SOC_FUSES_FT1_DATA",
      type: "int",
      default: "12016",
      local: "true"
    },
    { name: "SocFusesFt1DataSize",
      desc: "Size of SOC_FUSES_FT1_DATA",
      type: "int",
      default: "384",
      local: "true"
    },
    { name: "SocFusesFt2DataOffset",
      desc: "Offset of SOC_FUSES_FT2_DATA",
      type: "int",
      default: "12400",
      local: "true"
    },
    { name: "SocFusesFt2DataSize",
      desc: "Size of SOC_FUSES_FT2_DATA",
      type: "int",
      default: "3840",
      local: "true"
    },
    { name: "SocFusesFtDigestOffset",
      desc: "Offset of SOC_FUSES_FT_DIGEST",
      type: "int",
      default: "16240",
      local: "true"
    },
    { name: "SocFusesFtDigestSize",
      desc: "Size of SOC_FUSES_FT_DIGEST",
      type: "int",
      default: "8",
      local: "true"
    },
    { name: "ScratchFusesOffset",
      desc: "Offset of the SCRATCH_FUSES partition",
      type: "int",
      default: "16248",
      local: "true"
    },
    { name: "ScratchFusesSize",
      desc: "Size of the SCRATCH_FUSES partition",
      type: "int",
      default: "3760",
      local: "true"
    },
    { name: "ScratchFusesDataOffset",
      desc: "Offset of SCRATCH_FUSES_DATA",
      type: "int",
      default: "16248",
      local: "true"
    },
    { name: "ScratchFusesDataSize",
      desc: "Size of SCRATCH_FUSES_DATA",
      type: "int",
      default: "3752",
      local: "true"
    },
    { name: "ScratchFusesZerOffset",
      desc: "Offset of SCRATCH_FUSES_ZER",
      type: "int",
      default: "20000",
      local: "true"
    },
    { name: "ScratchFusesZerSize",
      desc: "Size of SCRATCH_FUSES_ZER",
      type: "int",
      default: "8",
      local: "true"
    },
    { name: "HwCfg0Offset",
      desc: "Offset of the HW_CFG0 partition",
      type: "int",
      default: "20008",
      local: "true"
    },
    { name: "HwCfg0Size",
      desc: "Size of the HW_CFG0 partition",
      type: "int",
      default: "48",
      local: "true"
    },
    { name: "DeviceIdOffset",
      desc: "Offset of DEVICE_ID",
      type: "int",
      default: "20008",
      local: "true"
    },
    { name: "DeviceIdSize",
      desc: "Size of DEVICE_ID",
      type: "int",
      default: "32",
      local: "true"
    },
    { name: "HwCfg0DigestOffset",
      desc: "Offset of HW_CFG0_DIGEST",
      type: "int",
      default: "20040",
      local: "true"
    },
    { name: "HwCfg0DigestSize",
      desc: "Size of HW_CFG0_DIGEST",
      type: "int",
      default: "8",
      local: "true"
    },
    { name: "HwCfg0ZerOffset",
      desc: "Offset of HW_CFG0_ZER",
      type: "int",
      default: "20048",
      local: "true"
    },
    { name: "HwCfg0ZerSize",
      desc: "Size of HW_CFG0_ZER",
      type: "int",
      default: "8",
      local: "true"
    },
    { name: "HwCfg1Offset",
      desc: "Offset of the HW_CFG1 partition",
      type: "int",
      default: "20056",
      local: "true"
    },
    { name: "HwCfg1Size",
      desc: "Size of the HW_CFG1 partition",
      type: "int",
      default: "24",
      local: "true"
    },
    { name: "EnSramIfetchOffset",
      desc: "Offset of EN_SRAM_IFETCH",
      type: "int",
      default: "20056",
      local: "true"
    },
    { name: "EnSramIfetchSize",
      desc: "Size of EN_SRAM_IFETCH",
      type: "int",
      default: "1",
      local: "true"
    },
    { name: "EnCsrngSwAppReadOffset",
      desc: "Offset of EN_CSRNG_SW_APP_READ",
      type: "int",
      default: "20057",
      local: "true"
    },
    { name: "EnCsrngSwAppReadSize",
      desc: "Size of EN_CSRNG_SW_APP_READ",
      type: "int",
      default: "1",
      local: "true"
    },
    { name: "DisRvDmLateDebugOffset",
      desc: "Offset of DIS_RV_DM_LATE_DEBUG",
      type: "int",
      default: "20058",
      local: "true"
    },
    { name: "DisRvDmLateDebugSize",
      desc: "Size of DIS_RV_DM_LATE_DEBUG",
      type: "int",
      default: "1",
      local: "true"
    },
    { name: "HwCfg1DigestOffset",
      desc: "Offset of HW_CFG1_DIGEST",
      type: "int",
      default: "20064",
      local: "true"
    },
    { name: "HwCfg1DigestSize",
      desc: "Size of HW_CFG1_DIGEST",
      type: "int",
      default: "8",
      local: "true"
    },
    { name: "HwCfg1ZerOffset",
      desc: "Offset of HW_CFG1_ZER",
      type: "int",
      default: "20072",
      local: "true"
    },
    { name: "HwCfg1ZerSize",
      desc: "Size of HW_CFG1_ZER",
      type: "int",
      default: "8",
      local: "true"
    },
    { name: "HwCfg2Offset",
      desc: "Offset of the HW_CFG2 partition",
      type: "int",
      default: "20080",
      local: "true"
    },
    { name: "HwCfg2Size",
      desc: "Size of the HW_CFG2 partition",
      type: "int",
      default: "56",
      local: "true"
    },
    { name: "SocDbgStateOffset",
      desc: "Offset of SOC_DBG_STATE",
      type: "int",
      default: "20080",
      local: "true"
    },
    { name: "SocDbgStateSize",
      desc: "Size of SOC_DBG_STATE",
      type: "int",
      default: "4",
      local: "true"
    },
    { name: "ManufStateOffset",
      desc: "Offset of MANUF_STATE",
      type: "int",
      default: "20084",
      local: "true"
    },
    { name: "ManufStateSize",
      desc: "Size of MANUF_STATE",
      type: "int",
      default: "32",
      local: "true"
    },
    { name: "HwCfg2DigestOffset",
      desc: "Offset of HW_CFG2_DIGEST",
      type: "int",
      default: "20120",
      local: "true"
    },
    { name: "HwCfg2DigestSize",
      desc: "Size of HW_CFG2_DIGEST",
      type: "int",
      default: "8",
      local: "true"
    },
    { name: "HwCfg2ZerOffset",
      desc: "Offset of HW_CFG2_ZER",
      type: "int",
      default: "20128",
      local: "true"
    },
    { name: "HwCfg2ZerSize",
      desc: "Size of HW_CFG2_ZER",
      type: "int",
      default: "8",
      local: "true"
    },
    { name: "Secret0Offset",
      desc: "Offset of the SECRET0 partition",
      type: "int",
      default: "20136",
      local: "true"
    },
    { name: "Secret0Size",
      desc: "Size of the SECRET0 partition",
      type: "int",
      default: "48",
      local: "true"
    },
    { name: "TestUnlockTokenOffset",
      desc: "Offset of TEST_UNLOCK_TOKEN",
      type: "int",
      default: "20136",
      local: "true"
    },
    { name: "TestUnlockTokenSize",
      desc: "Size of TEST_UNLOCK_TOKEN",
      type: "int",
      default: "16",
      local: "true"
    },
    { name: "TestExitTokenOffset",
      desc: "Offset of TEST_EXIT_TOKEN",
      type: "int",
      default: "20152",
      local: "true"
    },
    { name: "TestExitTokenSize",
      desc: "Size of TEST_EXIT_TOKEN",
      type: "int",
      default: "16",
      local: "true"
    },
    { name: "Secret0DigestOffset",
      desc: "Offset of SECRET0_DIGEST",
      type: "int",
      default: "20168",
      local: "true"
    },
    { name: "Secret0DigestSize",
      desc: "Size of SECRET0_DIGEST",
      type: "int",
      default: "8",
      local: "true"
    },
    { name: "Secret0ZerOffset",
      desc: "Offset of SECRET0_ZER",
      type: "int",
      default: "20176",
      local: "true"
    },
    { name: "Secret0ZerSize",
      desc: "Size of SECRET0_ZER",
      type: "int",
      default: "8",
      local: "true"
    },
    { name: "Secret1Offset",
      desc: "Offset of the SECRET1 partition",
      type: "int",
      default: "20184",
      local: "true"
    },
    { name: "Secret1Size",
      desc: "Size of the SECRET1 partition",
      type: "int",
      default: "32",
      local: "true"
    },
    { name: "SramDataKeySeedOffset",
      desc: "Offset of SRAM_DATA_KEY_SEED",
      type: "int",
      default: "20184",
      local: "true"
    },
    { name: "SramDataKeySeedSize",
      desc: "Size of SRAM_DATA_KEY_SEED",
      type: "int",
      default: "16",
      local: "true"
    },
    { name: "Secret1DigestOffset",
      desc: "Offset of SECRET1_DIGEST",
      type: "int",
      default: "20200",
      local: "true"
    },
    { name: "Secret1DigestSize",
      desc: "Size of SECRET1_DIGEST",
      type: "int",
      default: "8",
      local: "true"
    },
    { name: "Secret1ZerOffset",
      desc: "Offset of SECRET1_ZER",
      type: "int",
      default: "20208",
      local: "true"
    },
    { name: "Secret1ZerSize",
      desc: "Size of SECRET1_ZER",
      type: "int",
      default: "8",
      local: "true"
    },
    { name: "Secret2Offset",
      desc: "Offset of the SECRET2 partition",
      type: "int",
      default: "20216",
      local: "true"
    },
    { name: "Secret2Size",
      desc: "Size of the SECRET2 partition",
      type: "int",
      default: "128",
      local: "true"
    },
    { name: "RmaTokenOffset",
      desc: "Offset of RMA_TOKEN",
      type: "int",
      default: "20216",
      local: "true"
    },
    { name: "RmaTokenSize",
      desc: "Size of RMA_TOKEN",
      type: "int",
      default: "16",
      local: "true"
    },
    { name: "CreatorRootKeyShare0Offset",
      desc: "Offset of CREATOR_ROOT_KEY_SHARE0",
      type: "int",
      default: "20232",
      local: "true"
    },
    { name: "CreatorRootKeyShare0Size",
      desc: "Size of CREATOR_ROOT_KEY_SHARE0",
      type: "int",
      default: "32",
      local: "true"
    },
    { name: "CreatorRootKeyShare1Offset",
      desc: "Offset of CREATOR_ROOT_KEY_SHARE1",
      type: "int",
      default: "20264",
      local: "true"
    },
    { name: "CreatorRootKeyShare1Size",
      desc: "Size of CREATOR_ROOT_KEY_SHARE1",
      type: "int",
      default: "32",
      local: "true"
    },
    { name: "CreatorSeedOffset",
      desc: "Offset of CREATOR_SEED",
      type: "int",
      default: "20296",
      local: "true"
    },
    { name: "CreatorSeedSize",
      desc: "Size of CREATOR_SEED",
      type: "int",
      default: "32",
      local: "true"
    },
    { name: "Secret2DigestOffset",
      desc: "Offset of SECRET2_DIGEST",
      type: "int",
      default: "20328",
      local: "true"
    },
    { name: "Secret2DigestSize",
      desc: "Size of SECRET2_DIGEST",
      type: "int",
      default: "8",
      local: "true"
    },
    { name: "Secret2ZerOffset",
      desc: "Offset of SECRET2_ZER",
      type: "int",
      default: "20336",
      local: "true"
    },
    { name: "Secret2ZerSize",
      desc: "Size of SECRET2_ZER",
      type: "int",
      default: "8",
      local: "true"
    },
    { name: "Secret3Offset",
      desc: "Offset of the SECRET3 partition",
      type: "int",
      default: "20344",
      local: "true"
    },
    { name: "Secret3Size",
      desc: "Size of the SECRET3 partition",
      type: "int",
      default: "48",
      local: "true"
    },
    { name: "OwnerSeedOffset",
      desc: "Offset of OWNER_SEED",
      type: "int",
      default: "20344",
      local: "true"
    },
    { name: "OwnerSeedSize",
      desc: "Size of OWNER_SEED",
      type: "int",
      default: "32",
      local: "true"
    },
    { name: "Secret3DigestOffset",
      desc: "Offset of SECRET3_DIGEST",
      type: "int",
      default: "20376",
      local: "true"
    },
    { name: "Secret3DigestSize",
      desc: "Size of SECRET3_DIGEST",
      type: "int",
      default: "8",
      local: "true"
    },
    { name: "Secret3ZerOffset",
      desc: "Offset of SECRET3_ZER",
      type: "int",
      default: "20384",
      local: "true"
    },
    { name: "Secret3ZerSize",
      desc: "Size of SECRET3_ZER",
      type: "int",
      default: "8",
      local: "true"
    },
    { name: "LifeCycleOffset",
      desc: "Offset of the LIFE_CYCLE partition",
      type: "int",
      default: "20392",
      local: "true"
    },
    { name: "LifeCycleSize",
      desc: "Size of the LIFE_CYCLE partition",
      type: "int",
      default: "88",
      local: "true"
    },
    { name: "LcTransitionCntOffset",
      desc: "Offset of LC_TRANSITION_CNT",
      type: "int",
      default: "20392",
      local: "true"
    },
    { name: "LcTransitionCntSize",
      desc: "Size of LC_TRANSITION_CNT",
      type: "int",
      default: "48",
      local: "true"
    },
    { name: "LcStateOffset",
      desc: "Offset of LC_STATE",
      type: "int",
      default: "20440",
      local: "true"
    },
    { name: "LcStateSize",
      desc: "Size of LC_STATE",
      type: "int",
      default: "40",
      local: "true"
    },
  ]

  /////////////////////////////
  // Intermodule Connections //
  /////////////////////////////

  inter_signal_list: [
    // EDN interface
    { struct:  "edn"
      type:    "req_rsp"
      name:    "edn"
      act:     "req"
      package: "edn_pkg"
      desc:    "Entropy request to the entropy distribution network for LFSR reseeding and ephemeral key derivation."
    }
    // Power manager init command
    { struct:  "pwr_otp"
      type:    "req_rsp"
      name:    "pwr_otp"
      act:     "rsp"
      default: "'0"
      package: "pwrmgr_pkg"
      desc:    "Initialization request/acknowledge from/to power manager."
    }
    // LC transition command
    { struct:  "lc_otp_program"
      type:    "req_rsp"
      name:    "lc_otp_program"
      act:     "rsp"
      default: "'0"
      package: "otp_ctrl_pkg"
      desc:    "Life cycle state transition interface."
    }
    // Broadcast to LC
    { struct:  "otp_lc_data"
      type:    "uni"
      name:    "otp_lc_data"
      act:     "req"
      default: "'0"
      package: "otp_ctrl_pkg"
      desc:    '''
               Life cycle state output holding the current life cycle state,
               the value of the transition counter and the tokens needed for life cycle transitions.
               '''
    }
    // Broadcast from LC
    { struct:  "lc_tx"
      type:    "uni"
      name:    "lc_escalate_en"
      act:     "rcv"
      default: "lc_ctrl_pkg::Off"
      package: "lc_ctrl_pkg"
      desc:    '''
               Life cycle escalation enable coming from life cycle controller.
               This signal moves all FSMs within OTP into the error state.
               '''
    }
    { struct:  "lc_tx"
      type:    "uni"
      name:    "lc_creator_seed_sw_rw_en"
      act:     "rcv"
      default: "lc_ctrl_pkg::Off"
      package: "lc_ctrl_pkg"
      desc:    '''
               Provision enable qualifier coming from life cycle controller.
               This signal enables SW read / write access to the RMA_TOKEN and CREATOR_ROOT_KEY_SHARE0 and CREATOR_ROOT_KEY_SHARE1.
               '''
    }
    { struct:  "lc_tx"
      type:    "uni"
      name:    "lc_owner_seed_sw_rw_en"
      act:     "rcv"
      default: "lc_ctrl_pkg::Off"
      package: "lc_ctrl_pkg"
      desc:    '''
               Provision enable qualifier coming from life cycle controller.
               This signal enables SW read / write access to the OWNER_SEED.
               '''
    }
    { struct:  "lc_tx"
      type:    "uni"
      name:    "lc_seed_hw_rd_en"
      act:     "rcv"
      default: "lc_ctrl_pkg::Off"
      package: "lc_ctrl_pkg"
      desc:    '''
               Seed read enable coming from life cycle controller.
               This signal enables HW read access to the CREATOR_ROOT_KEY_SHARE0 and CREATOR_ROOT_KEY_SHARE1.
               '''
    }
    { struct:  "lc_tx"
      type:    "uni"
      name:    "lc_rma_state"
      act:     "rcv"
      default: "lc_ctrl_pkg::Off"
      package: "lc_ctrl_pkg"
      desc:    '''
               This signal states whether the current life cycle is RMA.
               It is used to enable SW read access to (read-locked) partitions in the RMA state.
               '''
    }
    { struct:  "lc_tx"
      type:    "uni"
      name:    "lc_check_byp_en"
      act:     "rcv"
      default: "lc_ctrl_pkg::Off"
      package: "lc_ctrl_pkg"
      desc:    '''
               Life cycle partition check bypass signal.
               This signal causes the life cycle partition to bypass consistency checks during life cycle state transitions in order to prevent spurious consistency check failures.
               '''
    }
    // Broadcast to Key Manager
    { struct:  "otp_keymgr_key"
      type:    "uni"
      name:    "otp_keymgr_key"
      act:     "req"
      default: "'0"
      package: "otp_ctrl_pkg"
      desc:    "Key output to the key manager holding CREATOR_ROOT_KEY_SHARE0 and CREATOR_ROOT_KEY_SHARE1."
    }
    // Key request from SRAM scramblers
    { struct:  "sram_otp_key"
      // TODO: would be nice if this could accept parameters.
      // Split this out into an issue.
      width:   "4"
      type:    "req_rsp"
      name:    "sram_otp_key"
      act:     "rsp"
      default: "'0"
      package: "otp_ctrl_pkg"
      desc:    "Array with key derivation interfaces for SRAM scrambling devices."
    }
    // Key request from ACC RAM Scrambler
    { struct:  "acc_otp_key"
      type:    "req_rsp"
      name:    "acc_otp_key"
      act:     "rsp"
      default: "'0"
      package: "otp_ctrl_pkg"
      desc:    "Key derivation interface for ACC scrambling devices."
    }
    // Hardware config partition
    { struct:  "otp_broadcast"
      type:    "uni"
      name:    "otp_broadcast"
      act:     "req"
      default: "'0"
      package: "otp_ctrl_part_pkg"
      desc:    "Output of the HW partitions with breakout data types."
    }
    // OTP_MACRO Interface
    { struct:  "otp_ctrl_macro"
      type:    "req_rsp"
      name:    "otp_macro"
      act:     "req"
      default: "'0"
      package: "otp_ctrl_macro_pkg"
      desc:    "Data interface for the OTP macro."
    }
  ] // inter_signal_list

  /////////////////////
  // Countermeasures //
  /////////////////////

  countermeasures: [
    { name: "BUS.INTEGRITY",
      desc: "End-to-end bus integrity scheme."
    }
    { name: "SECRET.MEM.SCRAMBLE",
      desc: "Secret partitions are scrambled with a full-round PRESENT cipher."
    }
    { name: "PART.MEM.DIGEST",
      desc: "Integrity of buffered partitions is ensured via a 64bit digest."
    }
    { name: "DAI.FSM.SPARSE",
      desc: "The direct access interface FSM is sparsely encoded."
    }
    { name: "KDI.FSM.SPARSE",
      desc: "The key derivation interface FSM is sparsely encoded."
    }
    { name: "LCI.FSM.SPARSE",
      desc: "The life cycle interface FSM is sparsely encoded."
    }
    { name: "PART.FSM.SPARSE",
      desc: "The partition FSMs are sparsely encoded."
    }
    { name: "SCRMBL.FSM.SPARSE",
      desc: "The scramble datapath FSM is sparsely encoded."
    }
    { name: "TIMER.FSM.SPARSE",
      desc: "The background check timer FSM is sparsely encoded."
    }
    { name: "DAI.CTR.REDUN",
      desc: "The direct access interface address counter employs a cross-counter implementation."
    }
    { name: "KDI_SEED.CTR.REDUN",
      desc: "The key derivation interface counter employs a cross-counter implementation."
    }
    { name: "KDI_ENTROPY.CTR.REDUN",
      desc: "The key derivation entropy counter employs a cross-counter implementation."
    }
    { name: "LCI.CTR.REDUN",
      desc: "The life cycle interface address counter employs a cross-counter implementation."
    }
    { name: "PART.CTR.REDUN",
      desc: "The address counter of buffered partitions employs a cross-counter implementation."
    }
    { name: "SCRMBL.CTR.REDUN",
      desc: "The srambling datapath counter employs a cross-counter implementation."
    }
    { name: "TIMER_INTEG.CTR.REDUN",
      desc: "The background integrity check timer employs a duplicated counter implementation."
    }
    { name: "TIMER_CNSTY.CTR.REDUN",
      desc: "The background consistency check timer employs a duplicated counter implementation."
    }
    { name: "TIMER.LFSR.REDUN",
      desc: "The background check LFSR is duplicated."
    }
    { name: "DAI.FSM.LOCAL_ESC",
      desc: "The direct access interface FSM is moved into an invalid state upon local escalation."
    }
    { name: "LCI.FSM.LOCAL_ESC",
      desc: "The life cycle interface FSM is moved into an invalid state upon local escalation."
    }
    { name: "KDI.FSM.LOCAL_ESC",
      desc: "The key derivation interface FSM is moved into an invalid state upon local escalation."
    }
    { name: "PART.FSM.LOCAL_ESC",
      desc: "The partition FSMs are moved into an invalid state upon local escalation."
    }
    { name: "SCRMBL.FSM.LOCAL_ESC",
      desc: "The scramble datapath FSM is moved into an invalid state upon local escalation."
    }
    { name: "TIMER.FSM.LOCAL_ESC",
      desc: "The background check timer FSM is moved into an invalid state upon local escalation."
    }
    { name: "DAI.FSM.GLOBAL_ESC",
      desc: "The direct access interface FSM is moved into an invalid state upon global escalation via life cycle."
    }
    { name: "LCI.FSM.GLOBAL_ESC",
      desc: "The life cycle interface FSM is moved into an invalid state upon global escalation via life cycle."
    }
    { name: "KDI.FSM.GLOBAL_ESC",
      desc: "The key derivation interface FSM is moved into an invalid state upon global escalation via life cycle."
    }
    { name: "PART.FSM.GLOBAL_ESC",
      desc: "The partition FSMs are moved into an invalid state upon global escalation via life cycle."
    }
    { name: "SCRMBL.FSM.GLOBAL_ESC",
      desc: "The scramble datapath FSM is moved into an invalid state upon global escalation via life cycle."
    }
    { name: "TIMER.FSM.GLOBAL_ESC",
      desc: "The background check timer FSM is moved into an invalid state upon global escalation via life cycle."
    }
    { name: "PART.DATA_REG.INTEGRITY",
      desc: "All partition buffer registers are protected with ECC on 64bit blocks."
    }
    { name: "PART.DATA_REG.BKGN_CHK",
      desc: "The digest of buffered partitions is recomputed and checked at pseudorandom intervals in the background."
    }
    { name: "PART.MEM.REGREN"
      desc: "Unbuffered ('software') partitions can be read-locked via a CSR until the next system reset."
    }
    { name: "PART.MEM.SW_UNREADABLE"
      desc: "Secret buffered partitions become unreadable to software once they are locked via the digest."
    }
    { name: "PART.MEM.SW_UNWRITABLE"
      desc: "All partitions become unwritable by software once they are locked via the digest."
    }
    { name: "LC_PART.MEM.SW_NOACCESS"
      desc: "The life cycle partition is not directly readable nor writable via software."
    }
    { name: "ACCESS.CTRL.MUBI",
      desc: "The access control signals going from the partitions to the DAI are MUBI encoded."
    }
    { name: "TOKEN_VALID.CTRL.MUBI",
      desc: "The token valid signals going to the life cycle controller are MUBI encoded."
    }
    { name: "LC_CTRL.INTERSIG.MUBI",
      desc: "The life cycle control signals are multibit encoded."
    }
    { name: "DIRECT_ACCESS.CONFIG.REGWEN",
      desc: "The direct access CSRs are REGWEN protected."
    }
    { name: "CHECK_TRIGGER.CONFIG.REGWEN",
      desc: "The check trigger CSR is REGWEN protected."
    }
    { name: "CHECK.CONFIG.REGWEN",
      desc: "The check CSR is REGWEN protected."
    }
  ]

  features: [
    {
      name: "OTP_CTRL.PARTITION.VENDOR_TEST"
      desc: '''Vendor test partition is used for OTP programming smoke check during manufacturing flow.
      In this partition, ECC uncorrectable errors will not lead to fatal errors and alerts.
      Instead the error will be reported as correctable ECC error.
      '''
    }
    {
      name: "OTP_CTRL.PARTITION.CREATOR_SW_CFG"
      desc: '''During calibration stage, various parameters (clock, voltage, and timing sources) are calibrated and recorded to CREATOR_SW_CFG partition.
      '''
    }
    {
      name: "OTP_CTRL.PARTITION.OWNER_SW_CFG"
      desc: "Define attributes for rom code execution"
    }
    {
      name: "OTP_CTRL.INIT"
      desc: '''When power is up, OTP controller reads devices status.
      After all reads complete, the controller performs integrity check on the HW_CFG* and SECRET partitions.
      Once all integrity checks are complete, the controller marks outputs as valid.
      '''
    }
    {
      name: "OTP_CTRL.ENTROPY_READ"
      desc: '''Firmware can read entropy from ENTROPY_SRC block by configuring following field of HW_CFG* partition.
        - EN_CSRNG_SW_APP_READ
      '''
    }
    {
      name: "OTP_CTRL.KEY_DERIVATION"
      desc: "OTP controller participate key derivation process by providing scramble key seed to SRAM_CTRL."
    }
    {
      name: "OTP_CTRL.PROGRAM"
      desc: '''All other partitions except life cycle partition are programmed through DAI interface.
      And once non-zero digest is programmed to these partition, no further write access is allowed.
      Life cycle partition is programmed by LC_CTRL.
      '''
    }
    {
      name: "OTP_CTRL.PARTITION.SECRET0"
      desc: "Test unlock tokens, Test exit token"
    }
    {
      name: "OTP_CTRL.PARTITION.SECRET1"
      desc: "SRAM scrambling key"
    }
    {
      name: "OTP_CTRL.PARTITION.SECRET2"
      desc: "RMA unlock token and creator root key"
    }
    {
      name: "OTP_CTRL.PARTITION.LIFE_CYCLE"
      desc: '''LC state, LC transition count.
      This feature is owned by the LC_CTRL and cannot be tested well through the OTP_CTRL CSR interface.
      '''
    }
    {
      name: "OTP_CTRL.PARTITIONS_FEATURE.READ_LOCK"
      desc: '''Following partitions can be read lockable by CSR.
                 - VENDOR_TEST
                 - CREATOR_SW_CFG
                 - OWNER_SW_CFG
               Following partitions can be read lockable by writing digest.
                 - SECRET0
                 - SECRET1
                 - RECRET2
      All read attempt to these partitions after read is locked will trigger AccessError (recoverable).
      '''
    }
    {
      name: "OTP_CTRL.PARTITIONS_FEATURE.WRITE_LOCK"
      desc: "All partitions except LIFE_CYCLE can be write lockable by writing digest."
    }
    {
      name: "OTP_CTRL.ERROR_HANDLING.RECOVERABLE"
      desc: "Recoverable error is created when unauthorized access attempt are detected via dai interface."
    }
    {
      name: "OTP_CTRL.ERROR_HANDLING.FATAL"
      desc: "Unrecoverable errors are created for uncorrectable ecc error, otp macro malfunction and unauthorized access via lc_ctrl."
    }
    {
      name: "OTP_CTRL.BACKGROUND_CHECK.CHECK_TIMEOUT"
      desc: "Timeout value for the integrity and consistency checks."
    }
    {
      name: "OTP_CTRL.BACKGROUND_CHECK.INTEGRITY_CHECK_PERIOD"
      desc: "The interval which the digest of the partition is recomputed to check integrity of locked partition."
    }
    {
      name: "OTP_CTRL.BACKGROUND_CHECK.CONSISTENCY_CHECK_PERIOD"
      desc: "Re-read period of the buffer registers to ensure data is matched with the associated OTP partition."
    }
  ]

  ///////////////
  // Registers //
  ///////////////

  regwidth: "32",
  registers: {
    core: [
      ////////////////////////
      // Ctrl / Status CSRs //
      ////////////////////////

      { name: "STATUS",
        desc: "OTP status register.",
        swaccess: "ro",
        hwaccess: "hwo",
        hwext:    "true",
        resval:   0,
        tags: [ // OTP internal HW can modify status register
                "excl:CsrAllTests:CsrExclCheck"],
        fields: [
          { bits: "0"
            name: "PARTITION_ERROR"
            desc: '''
                  Set to 1 if an error occurred in any partition.
                  If set to 1, SW should check the !!PARTITION_STATUS register to determine the failing partition.
                  '''
          }
          { bits: "1"
            name: "DAI_ERROR"
            desc: '''
                  Set to 1 if an error occurred in the DAI.
                  If set to 1, SW should check the !!ERR_CODE register at the corresponding index.
                  '''
          }
          { bits: "2"
            name: "LCI_ERROR"
            desc: '''
                  Set to 1 if an error occurred in the LCI.
                  If set to 1, SW should check the !!ERR_CODE register at the corresponding index.
                  '''
          }
          { bits: "3"
            name: "TIMEOUT_ERROR"
            desc: '''
                  Set to 1 if an integrity or consistency check times out.
                  This raises an fatal_check_error alert and is an unrecoverable error condition.
                  '''
          }
          { bits: "4"
            name: "LFSR_FSM_ERROR"
            desc: '''
                  Set to 1 if the LFSR timer FSM has reached an invalid state.
                  This raises an fatal_check_error alert and is an unrecoverable error condition.
                  '''
          }
          { bits: "5"
            name: "SCRAMBLING_FSM_ERROR"
            desc: '''
                  Set to 1 if the scrambling datapath FSM has reached an invalid state.
                  This raises an fatal_check_error alert and is an unrecoverable error condition.
                  '''
          }
          { bits: "6"
            name: "KEY_DERIV_FSM_ERROR"
            desc: '''
                  Set to 1 if the key derivation FSM has reached an invalid state.
                  This raises an fatal_check_error alert and is an unrecoverable error condition.
                  '''
          }
          { bits: "7"
            name: "BUS_INTEG_ERROR"
            desc: '''
                  This bit is set to 1 if a fatal bus integrity fault is detected.
                  This error triggers a fatal_bus_integ_error alert.
                  '''
          }
          { bits: "8"
            name: "DAI_IDLE"
            desc: "Set to 1 if the DAI is idle and ready to accept commands."
          }
          { bits: "9"
            name: "CHECK_PENDING"
            desc: "Set to 1 if an integrity or consistency check triggered by the LFSR timer or via !!CHECK_TRIGGER is pending."
          }
        ]
      }
      { name: "PARTITION_STATUS_0",
        desc: "OTP partition status register 0.",
        swaccess: "ro",
        hwaccess: "hwo",
        hwext:    "true",
        resval:   0,
        tags: [ // OTP internal HW can modify status register
                "excl:CsrAllTests:CsrExclCheck"],
        fields: [
          { bits: "0"
            name: "VENDOR_TEST_ERROR"
            desc: '''
                  Set to 1 if an error occurred in this partition.
                  If set to 1, SW should check the !!ERR_CODE register at the corresponding index.
                  '''
          }
          { bits: "1"
            name: "CREATOR_SW_CFG_ERROR"
            desc: '''
                  Set to 1 if an error occurred in this partition.
                  If set to 1, SW should check the !!ERR_CODE register at the corresponding index.
                  '''
          }
          { bits: "2"
            name: "OWNER_SW_CFG_ERROR"
            desc: '''
                  Set to 1 if an error occurred in this partition.
                  If set to 1, SW should check the !!ERR_CODE register at the corresponding index.
                  '''
          }
          { bits: "3"
            name: "OWNERSHIP_SLOT_STATE_ERROR"
            desc: '''
                  Set to 1 if an error occurred in this partition.
                  If set to 1, SW should check the !!ERR_CODE register at the corresponding index.
                  '''
          }
          { bits: "4"
            name: "ROT_OWNER_AUTH_SLOT0_ERROR"
            desc: '''
                  Set to 1 if an error occurred in this partition.
                  If set to 1, SW should check the !!ERR_CODE register at the corresponding index.
                  '''
          }
          { bits: "5"
            name: "ROT_OWNER_AUTH_SLOT1_ERROR"
            desc: '''
                  Set to 1 if an error occurred in this partition.
                  If set to 1, SW should check the !!ERR_CODE register at the corresponding index.
                  '''
          }
          { bits: "6"
            name: "ROT_OWNER_AUTH_SLOT2_ERROR"
            desc: '''
                  Set to 1 if an error occurred in this partition.
                  If set to 1, SW should check the !!ERR_CODE register at the corresponding index.
                  '''
          }
          { bits: "7"
            name: "ROT_OWNER_AUTH_SLOT3_ERROR"
            desc: '''
                  Set to 1 if an error occurred in this partition.
                  If set to 1, SW should check the !!ERR_CODE register at the corresponding index.
                  '''
          }
          { bits: "8"
            name: "ROT_OWNER_AUTH_SLOT0_STATE_ERROR"
            desc: '''
                  Set to 1 if an error occurred in this partition.
                  If set to 1, SW should check the !!ERR_CODE register at the corresponding index.
                  '''
          }
          { bits: "9"
            name: "ROT_OWNER_AUTH_SLOT1_STATE_ERROR"
            desc: '''
                  Set to 1 if an error occurred in this partition.
                  If set to 1, SW should check the !!ERR_CODE register at the corresponding index.
                  '''
          }
          { bits: "10"
            name: "ROT_OWNER_AUTH_SLOT2_STATE_ERROR"
            desc: '''
                  Set to 1 if an error occurred in this partition.
                  If set to 1, SW should check the !!ERR_CODE register at the corresponding index.
                  '''
          }
          { bits: "11"
            name: "ROT_OWNER_AUTH_SLOT3_STATE_ERROR"
            desc: '''
                  Set to 1 if an error occurred in this partition.
                  If set to 1, SW should check the !!ERR_CODE register at the corresponding index.
                  '''
          }
          { bits: "12"
            name: "EXT_NVM_ERROR"
            desc: '''
                  Set to 1 if an error occurred in this partition.
                  If set to 1, SW should check the !!ERR_CODE register at the corresponding index.
                  '''
          }
          { bits: "13"
            name: "ROM_PATCH_ERROR"
            desc: '''
                  Set to 1 if an error occurred in this partition.
                  If set to 1, SW should check the !!ERR_CODE register at the corresponding index.
                  '''
          }
          { bits: "14"
            name: "SOC_FUSES_CP_ERROR"
            desc: '''
                  Set to 1 if an error occurred in this partition.
                  If set to 1, SW should check the !!ERR_CODE register at the corresponding index.
                  '''
          }
          { bits: "15"
            name: "SOC_FUSES_FT_ERROR"
            desc: '''
                  Set to 1 if an error occurred in this partition.
                  If set to 1, SW should check the !!ERR_CODE register at the corresponding index.
                  '''
          }
          { bits: "16"
            name: "SCRATCH_FUSES_ERROR"
            desc: '''
                  Set to 1 if an error occurred in this partition.
                  If set to 1, SW should check the !!ERR_CODE register at the corresponding index.
                  '''
          }
          { bits: "17"
            name: "HW_CFG0_ERROR"
            desc: '''
                  Set to 1 if an error occurred in this partition.
                  If set to 1, SW should check the !!ERR_CODE register at the corresponding index.
                  '''
          }
          { bits: "18"
            name: "HW_CFG1_ERROR"
            desc: '''
                  Set to 1 if an error occurred in this partition.
                  If set to 1, SW should check the !!ERR_CODE register at the corresponding index.
                  '''
          }
          { bits: "19"
            name: "HW_CFG2_ERROR"
            desc: '''
                  Set to 1 if an error occurred in this partition.
                  If set to 1, SW should check the !!ERR_CODE register at the corresponding index.
                  '''
          }
          { bits: "20"
            name: "SECRET0_ERROR"
            desc: '''
                  Set to 1 if an error occurred in this partition.
                  If set to 1, SW should check the !!ERR_CODE register at the corresponding index.
                  '''
          }
          { bits: "21"
            name: "SECRET1_ERROR"
            desc: '''
                  Set to 1 if an error occurred in this partition.
                  If set to 1, SW should check the !!ERR_CODE register at the corresponding index.
                  '''
          }
          { bits: "22"
            name: "SECRET2_ERROR"
            desc: '''
                  Set to 1 if an error occurred in this partition.
                  If set to 1, SW should check the !!ERR_CODE register at the corresponding index.
                  '''
          }
          { bits: "23"
            name: "SECRET3_ERROR"
            desc: '''
                  Set to 1 if an error occurred in this partition.
                  If set to 1, SW should check the !!ERR_CODE register at the corresponding index.
                  '''
          }
          { bits: "24"
            name: "LIFE_CYCLE_ERROR"
            desc: '''
                  Set to 1 if an error occurred in this partition.
                  If set to 1, SW should check the !!ERR_CODE register at the corresponding index.
                  '''
          }
        ]
      }
      { multireg: {
          name:     "ERR_CODE",
          desc:     '''
                    This register holds information about error conditions that occurred in the agents
                    interacting with the OTP macro via the internal bus. The error codes should be checked
                    if the partitions, DAI or LCI flag an error in the !!STATUS register, or when an
                    !!INTR_STATE.otp_error has been triggered. Note that all errors trigger an otp_error
                    interrupt, and in addition some errors may trigger either an fatal_macro_error or an
                    fatal_check_error alert.
                    ''',
          count:     "NumErrorEntries",
          swaccess:  "ro",
          hwaccess:  "hwo",
          hwext:     "true",
          cname:     "AGENT",
          compact:   "false",
          resval:    0,
          tags: [ // OTP internal HW can modify the error code registers
                  "excl:CsrAllTests:CsrExclCheck"],
          fields: [
            {
              bits: "2:0"
              enum: [
                { value: "0",
                  name: "NO_ERROR",
                  desc: '''
                  No error condition has occurred.
                  '''
                },
                { value: "1",
                  name: "MACRO_ERROR",
                  desc: '''
                  Returned if the OTP macro command was invalid or did not complete successfully
                  due to a macro malfunction.
                  This error should never occur during normal operation and is not recoverable.
                  This error triggers an fatal_macro_error alert.
                  '''
                },
                { value: "2",
                  name: "MACRO_ECC_CORR_ERROR",
                  desc: '''
                  A correctable ECC error has occurred during an OTP read operation.
                  The corresponding controller automatically recovers from this error when
                  issuing a new command.
                  '''
                },
                { value: "3",
                  name: "MACRO_ECC_UNCORR_ERROR",
                  desc: '''
                  An uncorrectable ECC error has occurred during an OTP read operation.
                  This error should never occur during normal operation and is not recoverable.
                  If this error is present this may be a sign that the device is malfunctioning.
                  This error triggers an fatal_macro_error alert.
                  '''
                },
                { value: "4",
                  name: "MACRO_WRITE_BLANK_ERROR",
                  desc: '''
                  This error is returned if a programming operation attempted to clear a bit that has previously been programmed to 1.
                  The corresponding controller automatically recovers from this error when issuing a new command.

                  Note however that the affected OTP word may be left in an inconsistent state if this error occurs.
                  This can cause several issues when the word is accessed again (either as part of a regular read operation, as part of the readout at boot, or as part of a background check).

                  It is important that SW ensures that each word is only written once, since this can render the device useless.
                  '''
                },
                { value: "5",
                  name: "ACCESS_ERROR",
                  desc: '''
                  This error indicates that a locked memory region has been accessed.
                  The corresponding controller automatically recovers from this error when issuing a new command.
                  '''
                },
                { value: "6",
                  name: "CHECK_FAIL_ERROR",
                  desc: '''
                  An ECC, integrity or consistency mismatch has been detected in the buffer registers.
                  This error should never occur during normal operation and is not recoverable.
                  This error triggers an fatal_check_error alert.
                  '''
                },
                { value: "7",
                  name: "FSM_STATE_ERROR",
                  desc: '''
                  The FSM of the corresponding controller has reached an invalid state, or the FSM has
                  been moved into a terminal error state due to an escalation action via lc_escalate_en_i.
                  This error should never occur during normal operation and is not recoverable.
                  If this error is present, this is a sign that the device has fallen victim to
                  an invasive attack. This error triggers an fatal_check_error alert.
                  '''
                },
              ]
            }
          ]
        }
      }
      { name: "DIRECT_ACCESS_REGWEN",
        desc: '''
              Register write enable for all direct access interface registers.
              ''',
        swaccess: "rw0c",
        hwaccess: "hrw",
        hwext:    "true",
        hwqe:     "true",
        tags: [ // OTP internal HW will set this enable register to 0 when OTP is not under IDLE
                // state, so could not auto-predict its value
                "excl:CsrNonInitTests:CsrExclCheck"],
        fields: [
          {
              bits:   "0",
              desc: '''
              This bit controls whether the DAI registers can be written.
              Write 0 to it in order to clear the bit.

              Note that the hardware also modulates this bit and sets it to 0 temporarily
              during an OTP operation such that the corresponding address and data registers
              cannot be modified while an operation is pending. The !!DAI_IDLE status bit
              will also be set to 0 in such a case.
              '''
              resval: 1,
          },
        ]
      },
      { name: "DIRECT_ACCESS_CMD",
        desc: "Command register for direct accesses.",
        swaccess: "r0w1c",
        hwaccess: "hro",
        hwqe:     "true",
        hwext:    "true",
        resval:   0,
        regwen:   "DIRECT_ACCESS_REGWEN",
        tags: [ // Write to DIRECT_ACCESS_CMD randomly might cause OTP_ERRORs and illegal sequences
                "excl:CsrNonInitTests:CsrExclWrite"],
        fields: [
          { bits: "0",
            name: "RD",
            desc: '''
            Initiates a readout sequence that reads the location specified
            by !!DIRECT_ACCESS_ADDRESS. The command places the data read into
            !!DIRECT_ACCESS_RDATA_0 and !!DIRECT_ACCESS_RDATA_1 (for 64bit partitions).
            '''
          }
          { bits: "1",
            name: "WR",
            desc: '''
                  Initiates a programming sequence that writes the data in !!DIRECT_ACCESS_WDATA_0
                  and !!DIRECT_ACCESS_WDATA_1 (for 64bit partitions) to the location specified by
                  !!DIRECT_ACCESS_ADDRESS.
                  '''
          }
          { bits: "2",
            name: "DIGEST",
            desc: '''
                  Initiates the digest calculation and locking sequence for the partition specified by
                  !!DIRECT_ACCESS_ADDRESS.
                  '''
          }
          { bits: "3",
            name: "ZEROIZE",
            desc: '''
                  Initiates the zeroization sequence of location specified by !!DIRECT_ACCESS_ADDRESS.
                  The command places the resulting count of bits set into !!DIRECT_ACCESS_RDATA_0 if
                  the execution is successful.
                  '''
          }
        ]
      }
      { name: "DIRECT_ACCESS_ADDRESS",
        desc: "Address register for direct accesses.",
        swaccess: "rw",
        hwaccess: "hro",
        hwqe:     "false",
        resval:   0,
        regwen:   "DIRECT_ACCESS_REGWEN",
        tags: [ // The enable register "DIRECT_ACCESS_REGWEN" is HW controlled,
                // so not able to predict this register value automatically
                "excl:CsrNonInitTests:CsrExclCheck"],
        fields: [
          { bits: "OtpByteAddrWidth-1:0",
            desc: '''
                  This is the address for the OTP word to be read or written through
                  the direct access interface. Note that the address is aligned to the access size
                  internally, hence bits 1:0 are ignored for 32bit accesses, and bits 2:0 are ignored
                  for 64bit accesses.

                  For the digest calculation command, set this register to the partition base offset.
                  '''
          }
        ]
      }
      { multireg: {
          name:     "DIRECT_ACCESS_WDATA",
          desc:     '''Write data for direct accesses.
                    Hardware automatically determines the access granule (32bit or 64bit) based on which
                    partition is being written to.
                    ''',
          count:    "NumDaiWords", // 2 x 32bit = 64bit
          swaccess: "rw",
          hwaccess: "hro",
          hwqe:     "false",
          regwen:   "DIRECT_ACCESS_REGWEN",
          cname:    "WORD",
          resval:   0,
          tags: [ // The value of this register is written from "DIRECT_ACCESS_RDATA",
                  // so could not predict this register value automatically
                  "excl:CsrAllTests:CsrExclCheck"],
          fields: [
            { bits: "31:0"
            }
          ]
        }
      },
      { multireg: {
          name:     "DIRECT_ACCESS_RDATA",
          desc:     '''Read data for direct accesses.
                    Hardware automatically determines the access granule (32bit or 64bit) based on which
                    partition is read from.
                    ''',
          count:    "NumDaiWords", // 2 x 32bit = 64bit
          swaccess: "ro",
          hwaccess: "hwo",
          hwext:    "true",
          cname:    "WORD",
          resval:   0,
          fields: [
            { bits: "31:0"
            }
          ]
        }
      },

      //////////////////////////////////////
      // Integrity and Consistency Checks //
      //////////////////////////////////////
      { name: "CHECK_TRIGGER_REGWEN",
        desc: '''
              Register write enable for !!CHECK_TRIGGER.
              ''',
        swaccess: "rw0c",
        hwaccess: "none",
        fields: [
          { bits:   "0",
            desc: '''
            When cleared to 0, the !!CHECK_TRIGGER register cannot be written anymore.
            Write 0 to clear this bit.
            '''
            resval: 1,
          },
        ]
      },
      { name: "CHECK_TRIGGER",
        desc: "Command register for direct accesses.",
        swaccess: "r0w1c",
        hwaccess: "hro",
        hwqe:     "true",
        hwext:    "true",
        resval:   0,
        regwen:   "CHECK_TRIGGER_REGWEN",
        fields: [
          { bits: "0",
            name: "INTEGRITY",
            desc: '''
            Writing 1 to this bit triggers an integrity check. SW should monitor !!STATUS.CHECK_PENDING
            and wait until the check has been completed. If there are any errors, those will be flagged
            in the !!STATUS and !!ERR_CODE registers, and via the interrupts and alerts.
            '''
          }
          { bits: "1",
            name: "CONSISTENCY",
            desc: '''
            Writing 1 to this bit triggers a consistency check. SW should monitor !!STATUS.CHECK_PENDING
            and wait until the check has been completed. If there are any errors, those will be flagged
            in the !!STATUS and !!ERR_CODE registers, and via interrupts and alerts.
            '''
          }
        ]
      },
      { name: "CHECK_REGWEN",
        desc: '''
              Register write enable for !!INTEGRITY_CHECK_PERIOD and !!CONSISTENCY_CHECK_PERIOD.
              ''',
        swaccess: "rw0c",
        hwaccess: "none",
        fields: [
          { bits:   "0",
            desc: '''
            When cleared to 0, !!INTEGRITY_CHECK_PERIOD and !!CONSISTENCY_CHECK_PERIOD registers cannot be written anymore.
            Write 0 to clear this bit.
            '''
            resval: 1,
          },
        ]
      },
      { name: "CHECK_TIMEOUT",
        desc: '''
              Timeout value for the integrity and consistency checks.
              ''',
        swaccess: "rw",
        hwaccess: "hro",
        regwen:   "CHECK_REGWEN",
        tags: [ // Do not write to this automatically, as it may trigger fatal alert, and cause
                // escalation.
                "excl:CsrAllTests:CsrExclWrite"],
        fields: [
          { bits: "31:0",
            desc: '''
            Timeout value in cycles for the for the integrity and consistency checks. If an integrity or consistency
            check does not complete within the timeout window, an error will be flagged in the !!STATUS register,
            an otp_error interrupt will be raised, and an fatal_check_error alert will be sent out. The timeout should
            be set to a large value to stay on the safe side. The maximum check time can be upper bounded by the
            number of cycles it takes to readout, scramble and digest the entire OTP array. Since this amounts to
            roughly 25k cycles, it is recommended to set this value to at least 100'000 cycles in order to stay on the
            safe side. A value of zero disables the timeout mechanism (default).
            '''
            resval: 0,
          },
        ]
      },
      { name: "INTEGRITY_CHECK_PERIOD",
        desc: '''
              This value specifies the maximum period that can be generated pseudo-randomly.
              Only applies to the HW_CFG* and SECRET* partitions once they are locked.
              '''
        swaccess: "rw",
        hwaccess: "hro",
        regwen:   "CHECK_REGWEN",
        fields: [
          { bits: "31:0",
            desc: '''
            The pseudo-random period is generated using a 40bit LFSR internally, and this register defines
            the bit mask to be applied to the LFSR output in order to limit its range. The value of this
            register is left shifted by 8bits and the lower bits are set to 8'hFF in order to form the 40bit mask.
            A recommended value is 0x3_FFFF, corresponding to a maximum period of ~2.8s at 24MHz.
            A value of zero disables the timer (default). Note that a one-off check can always be triggered via
            !!CHECK_TRIGGER.INTEGRITY.
            '''
            resval: "0"
          }
        ]
      }
      { name: "CONSISTENCY_CHECK_PERIOD",
        desc: '''
              This value specifies the maximum period that can be generated pseudo-randomly.
              This applies to the LIFE_CYCLE partition and the HW_CFG* and SECRET* partitions once they are locked.
              '''
        swaccess: "rw",
        hwaccess: "hro",
        regwen:   "CHECK_REGWEN",
        fields: [
          { bits: "31:0",
            desc: '''
            The pseudo-random period is generated using a 40bit LFSR internally, and this register defines
            the bit mask to be applied to the LFSR output in order to limit its range. The value of this
            register is left shifted by 8bits and the lower bits are set to 8'hFF in order to form the 40bit mask.
            A recommended value is 0x3FF_FFFF, corresponding to a maximum period of ~716s at 24MHz.
            A value of zero disables the timer (default). Note that a one-off check can always be triggered via
            !!CHECK_TRIGGER.CONSISTENCY.
            '''
            resval: "0"
          }
        ]
      }

      ////////////////////////////////////
      // Dynamic Locks of SW Parititons //
      ////////////////////////////////////
      { name: "VENDOR_TEST_READ_LOCK",
        desc: '''
              Runtime read lock for the VENDOR_TEST partition.
              ''',
        swaccess: "rw0c",
        hwaccess: "hro",
        regwen:   "DIRECT_ACCESS_REGWEN",
        tags:     [ // The value of this register can affect the read access of the this
                    // partition's memory window. Excluding this register from writing can ensure
                    // memories have read and write access.
                    "excl:CsrNonInitTests:CsrExclWrite"],
        fields: [
          { bits:   "0",
            desc: '''
            When cleared to 0, read access to the VENDOR_TEST partition is locked.
            Write 0 to clear this bit.
            '''
            resval: 1,
          },
        ]
      },
      { name: "CREATOR_SW_CFG_READ_LOCK",
        desc: '''
              Runtime read lock for the CREATOR_SW_CFG partition.
              ''',
        swaccess: "rw0c",
        hwaccess: "hro",
        regwen:   "DIRECT_ACCESS_REGWEN",
        tags:     [ // The value of this register can affect the read access of the this
                    // partition's memory window. Excluding this register from writing can ensure
                    // memories have read and write access.
                    "excl:CsrNonInitTests:CsrExclWrite"],
        fields: [
          { bits:   "0",
            desc: '''
            When cleared to 0, read access to the CREATOR_SW_CFG partition is locked.
            Write 0 to clear this bit.
            '''
            resval: 1,
          },
        ]
      },
      { name: "OWNER_SW_CFG_READ_LOCK",
        desc: '''
              Runtime read lock for the OWNER_SW_CFG partition.
              ''',
        swaccess: "rw0c",
        hwaccess: "hro",
        regwen:   "DIRECT_ACCESS_REGWEN",
        tags:     [ // The value of this register can affect the read access of the this
                    // partition's memory window. Excluding this register from writing can ensure
                    // memories have read and write access.
                    "excl:CsrNonInitTests:CsrExclWrite"],
        fields: [
          { bits:   "0",
            desc: '''
            When cleared to 0, read access to the OWNER_SW_CFG partition is locked.
            Write 0 to clear this bit.
            '''
            resval: 1,
          },
        ]
      },
      { name: "OWNERSHIP_SLOT_STATE_READ_LOCK",
        desc: '''
              Runtime read lock for the OWNERSHIP_SLOT_STATE partition.
              ''',
        swaccess: "rw0c",
        hwaccess: "hro",
        regwen:   "DIRECT_ACCESS_REGWEN",
        tags:     [ // The value of this register can affect the read access of the this
                    // partition's memory window. Excluding this register from writing can ensure
                    // memories have read and write access.
                    "excl:CsrNonInitTests:CsrExclWrite"],
        fields: [
          { bits:   "0",
            desc: '''
            When cleared to 0, read access to the OWNERSHIP_SLOT_STATE partition is locked.
            Write 0 to clear this bit.
            '''
            resval: 1,
          },
        ]
      },
      { name: "ROT_OWNER_AUTH_SLOT0_READ_LOCK",
        desc: '''
              Runtime read lock for the ROT_OWNER_AUTH_SLOT0 partition.
              ''',
        swaccess: "rw0c",
        hwaccess: "hro",
        regwen:   "DIRECT_ACCESS_REGWEN",
        tags:     [ // The value of this register can affect the read access of the this
                    // partition's memory window. Excluding this register from writing can ensure
                    // memories have read and write access.
                    "excl:CsrNonInitTests:CsrExclWrite"],
        fields: [
          { bits:   "0",
            desc: '''
            When cleared to 0, read access to the ROT_OWNER_AUTH_SLOT0 partition is locked.
            Write 0 to clear this bit.
            '''
            resval: 1,
          },
        ]
      },
      { name: "ROT_OWNER_AUTH_SLOT1_READ_LOCK",
        desc: '''
              Runtime read lock for the ROT_OWNER_AUTH_SLOT1 partition.
              ''',
        swaccess: "rw0c",
        hwaccess: "hro",
        regwen:   "DIRECT_ACCESS_REGWEN",
        tags:     [ // The value of this register can affect the read access of the this
                    // partition's memory window. Excluding this register from writing can ensure
                    // memories have read and write access.
                    "excl:CsrNonInitTests:CsrExclWrite"],
        fields: [
          { bits:   "0",
            desc: '''
            When cleared to 0, read access to the ROT_OWNER_AUTH_SLOT1 partition is locked.
            Write 0 to clear this bit.
            '''
            resval: 1,
          },
        ]
      },
      { name: "ROT_OWNER_AUTH_SLOT2_READ_LOCK",
        desc: '''
              Runtime read lock for the ROT_OWNER_AUTH_SLOT2 partition.
              ''',
        swaccess: "rw0c",
        hwaccess: "hro",
        regwen:   "DIRECT_ACCESS_REGWEN",
        tags:     [ // The value of this register can affect the read access of the this
                    // partition's memory window. Excluding this register from writing can ensure
                    // memories have read and write access.
                    "excl:CsrNonInitTests:CsrExclWrite"],
        fields: [
          { bits:   "0",
            desc: '''
            When cleared to 0, read access to the ROT_OWNER_AUTH_SLOT2 partition is locked.
            Write 0 to clear this bit.
            '''
            resval: 1,
          },
        ]
      },
      { name: "ROT_OWNER_AUTH_SLOT3_READ_LOCK",
        desc: '''
              Runtime read lock for the ROT_OWNER_AUTH_SLOT3 partition.
              ''',
        swaccess: "rw0c",
        hwaccess: "hro",
        regwen:   "DIRECT_ACCESS_REGWEN",
        tags:     [ // The value of this register can affect the read access of the this
                    // partition's memory window. Excluding this register from writing can ensure
                    // memories have read and write access.
                    "excl:CsrNonInitTests:CsrExclWrite"],
        fields: [
          { bits:   "0",
            desc: '''
            When cleared to 0, read access to the ROT_OWNER_AUTH_SLOT3 partition is locked.
            Write 0 to clear this bit.
            '''
            resval: 1,
          },
        ]
      },
      { name: "ROT_OWNER_AUTH_SLOT0_STATE_READ_LOCK",
        desc: '''
              Runtime read lock for the ROT_OWNER_AUTH_SLOT0_STATE partition.
              ''',
        swaccess: "rw0c",
        hwaccess: "hro",
        regwen:   "DIRECT_ACCESS_REGWEN",
        tags:     [ // The value of this register can affect the read access of the this
                    // partition's memory window. Excluding this register from writing can ensure
                    // memories have read and write access.
                    "excl:CsrNonInitTests:CsrExclWrite"],
        fields: [
          { bits:   "0",
            desc: '''
            When cleared to 0, read access to the ROT_OWNER_AUTH_SLOT0_STATE partition is locked.
            Write 0 to clear this bit.
            '''
            resval: 1,
          },
        ]
      },
      { name: "ROT_OWNER_AUTH_SLOT1_STATE_READ_LOCK",
        desc: '''
              Runtime read lock for the ROT_OWNER_AUTH_SLOT1_STATE partition.
              ''',
        swaccess: "rw0c",
        hwaccess: "hro",
        regwen:   "DIRECT_ACCESS_REGWEN",
        tags:     [ // The value of this register can affect the read access of the this
                    // partition's memory window. Excluding this register from writing can ensure
                    // memories have read and write access.
                    "excl:CsrNonInitTests:CsrExclWrite"],
        fields: [
          { bits:   "0",
            desc: '''
            When cleared to 0, read access to the ROT_OWNER_AUTH_SLOT1_STATE partition is locked.
            Write 0 to clear this bit.
            '''
            resval: 1,
          },
        ]
      },
      { name: "ROT_OWNER_AUTH_SLOT2_STATE_READ_LOCK",
        desc: '''
              Runtime read lock for the ROT_OWNER_AUTH_SLOT2_STATE partition.
              ''',
        swaccess: "rw0c",
        hwaccess: "hro",
        regwen:   "DIRECT_ACCESS_REGWEN",
        tags:     [ // The value of this register can affect the read access of the this
                    // partition's memory window. Excluding this register from writing can ensure
                    // memories have read and write access.
                    "excl:CsrNonInitTests:CsrExclWrite"],
        fields: [
          { bits:   "0",
            desc: '''
            When cleared to 0, read access to the ROT_OWNER_AUTH_SLOT2_STATE partition is locked.
            Write 0 to clear this bit.
            '''
            resval: 1,
          },
        ]
      },
      { name: "ROT_OWNER_AUTH_SLOT3_STATE_READ_LOCK",
        desc: '''
              Runtime read lock for the ROT_OWNER_AUTH_SLOT3_STATE partition.
              ''',
        swaccess: "rw0c",
        hwaccess: "hro",
        regwen:   "DIRECT_ACCESS_REGWEN",
        tags:     [ // The value of this register can affect the read access of the this
                    // partition's memory window. Excluding this register from writing can ensure
                    // memories have read and write access.
                    "excl:CsrNonInitTests:CsrExclWrite"],
        fields: [
          { bits:   "0",
            desc: '''
            When cleared to 0, read access to the ROT_OWNER_AUTH_SLOT3_STATE partition is locked.
            Write 0 to clear this bit.
            '''
            resval: 1,
          },
        ]
      },
      { name: "EXT_NVM_READ_LOCK",
        desc: '''
              Runtime read lock for the EXT_NVM partition.
              ''',
        swaccess: "rw0c",
        hwaccess: "hro",
        regwen:   "DIRECT_ACCESS_REGWEN",
        tags:     [ // The value of this register can affect the read access of the this
                    // partition's memory window. Excluding this register from writing can ensure
                    // memories have read and write access.
                    "excl:CsrNonInitTests:CsrExclWrite"],
        fields: [
          { bits:   "0",
            desc: '''
            When cleared to 0, read access to the EXT_NVM partition is locked.
            Write 0 to clear this bit.
            '''
            resval: 1,
          },
        ]
      },
      { name: "ROM_PATCH_READ_LOCK",
        desc: '''
              Runtime read lock for the ROM_PATCH partition.
              ''',
        swaccess: "rw0c",
        hwaccess: "hro",
        regwen:   "DIRECT_ACCESS_REGWEN",
        tags:     [ // The value of this register can affect the read access of the this
                    // partition's memory window. Excluding this register from writing can ensure
                    // memories have read and write access.
                    "excl:CsrNonInitTests:CsrExclWrite"],
        fields: [
          { bits:   "0",
            desc: '''
            When cleared to 0, read access to the ROM_PATCH partition is locked.
            Write 0 to clear this bit.
            '''
            resval: 1,
          },
        ]
      },
      { name: "SOC_FUSES_CP_READ_LOCK",
        desc: '''
              Runtime read lock for the SOC_FUSES_CP partition.
              ''',
        swaccess: "rw0c",
        hwaccess: "hro",
        regwen:   "DIRECT_ACCESS_REGWEN",
        tags:     [ // The value of this register can affect the read access of the this
                    // partition's memory window. Excluding this register from writing can ensure
                    // memories have read and write access.
                    "excl:CsrNonInitTests:CsrExclWrite"],
        fields: [
          { bits:   "0",
            desc: '''
            When cleared to 0, read access to the SOC_FUSES_CP partition is locked.
            Write 0 to clear this bit.
            '''
            resval: 1,
          },
        ]
      },
      { name: "SOC_FUSES_FT_READ_LOCK",
        desc: '''
              Runtime read lock for the SOC_FUSES_FT partition.
              ''',
        swaccess: "rw0c",
        hwaccess: "hro",
        regwen:   "DIRECT_ACCESS_REGWEN",
        tags:     [ // The value of this register can affect the read access of the this
                    // partition's memory window. Excluding this register from writing can ensure
                    // memories have read and write access.
                    "excl:CsrNonInitTests:CsrExclWrite"],
        fields: [
          { bits:   "0",
            desc: '''
            When cleared to 0, read access to the SOC_FUSES_FT partition is locked.
            Write 0 to clear this bit.
            '''
            resval: 1,
          },
        ]
      },
      { name: "SCRATCH_FUSES_READ_LOCK",
        desc: '''
              Runtime read lock for the SCRATCH_FUSES partition.
              ''',
        swaccess: "rw0c",
        hwaccess: "hro",
        regwen:   "DIRECT_ACCESS_REGWEN",
        tags:     [ // The value of this register can affect the read access of the this
                    // partition's memory window. Excluding this register from writing can ensure
                    // memories have read and write access.
                    "excl:CsrNonInitTests:CsrExclWrite"],
        fields: [
          { bits:   "0",
            desc: '''
            When cleared to 0, read access to the SCRATCH_FUSES partition is locked.
            Write 0 to clear this bit.
            '''
            resval: 1,
          },
        ]
      },

      ///////////////////////
      // Integrity Digests //
      ///////////////////////
      { multireg: {
          name:     "VENDOR_TEST_DIGEST",
          desc:     '''
                    Integrity digest for the VENDOR_TEST partition.
                    The integrity digest is 0 by default. Software must write a non-zero
                    digest value via the direct access interface in order to lock the partition.
                    After a reset, write access to the VENDOR_TEST partition is locked and
                    the digest becomes visible in this CSR.
                    ''',
          count:     "NumDigestWords",
          swaccess:  "ro",
          hwaccess:  "hwo",
          hwext:     "true",
          cname:     "WORD",
          resval:    0,
          tags: [ // OTP internal HW will update status so can not auto-predict its value.
                  "excl:CsrAllTests:CsrExclCheck"],
          fields: [
            { bits: "31:0"
            }
          ]
        }
      },
      { multireg: {
          name:     "CREATOR_SW_CFG_DIGEST",
          desc:     '''
                    Integrity digest for the CREATOR_SW_CFG partition.
                    The integrity digest is 0 by default. Software must write a non-zero
                    digest value via the direct access interface in order to lock the partition.
                    After a reset, write access to the CREATOR_SW_CFG partition is locked and
                    the digest becomes visible in this CSR.
                    ''',
          count:     "NumDigestWords",
          swaccess:  "ro",
          hwaccess:  "hwo",
          hwext:     "true",
          cname:     "WORD",
          resval:    0,
          tags: [ // OTP internal HW will update status so can not auto-predict its value.
                  "excl:CsrAllTests:CsrExclCheck"],
          fields: [
            { bits: "31:0"
            }
          ]
        }
      },
      { multireg: {
          name:     "OWNER_SW_CFG_DIGEST",
          desc:     '''
                    Integrity digest for the OWNER_SW_CFG partition.
                    The integrity digest is 0 by default. Software must write a non-zero
                    digest value via the direct access interface in order to lock the partition.
                    After a reset, write access to the OWNER_SW_CFG partition is locked and
                    the digest becomes visible in this CSR.
                    ''',
          count:     "NumDigestWords",
          swaccess:  "ro",
          hwaccess:  "hwo",
          hwext:     "true",
          cname:     "WORD",
          resval:    0,
          tags: [ // OTP internal HW will update status so can not auto-predict its value.
                  "excl:CsrAllTests:CsrExclCheck"],
          fields: [
            { bits: "31:0"
            }
          ]
        }
      },
      { multireg: {
          name:     "ROT_OWNER_AUTH_SLOT0_DIGEST",
          desc:     '''
                    Integrity digest for the ROT_OWNER_AUTH_SLOT0 partition.
                    The integrity digest is 0 by default. Software must write a non-zero
                    digest value via the direct access interface in order to lock the partition.
                    After a reset, write access to the ROT_OWNER_AUTH_SLOT0 partition is locked and
                    the digest becomes visible in this CSR.
                    ''',
          count:     "NumDigestWords",
          swaccess:  "ro",
          hwaccess:  "hwo",
          hwext:     "true",
          cname:     "WORD",
          resval:    0,
          tags: [ // OTP internal HW will update status so can not auto-predict its value.
                  "excl:CsrAllTests:CsrExclCheck"],
          fields: [
            { bits: "31:0"
            }
          ]
        }
      },
      { multireg: {
          name:     "ROT_OWNER_AUTH_SLOT1_DIGEST",
          desc:     '''
                    Integrity digest for the ROT_OWNER_AUTH_SLOT1 partition.
                    The integrity digest is 0 by default. Software must write a non-zero
                    digest value via the direct access interface in order to lock the partition.
                    After a reset, write access to the ROT_OWNER_AUTH_SLOT1 partition is locked and
                    the digest becomes visible in this CSR.
                    ''',
          count:     "NumDigestWords",
          swaccess:  "ro",
          hwaccess:  "hwo",
          hwext:     "true",
          cname:     "WORD",
          resval:    0,
          tags: [ // OTP internal HW will update status so can not auto-predict its value.
                  "excl:CsrAllTests:CsrExclCheck"],
          fields: [
            { bits: "31:0"
            }
          ]
        }
      },
      { multireg: {
          name:     "ROT_OWNER_AUTH_SLOT2_DIGEST",
          desc:     '''
                    Integrity digest for the ROT_OWNER_AUTH_SLOT2 partition.
                    The integrity digest is 0 by default. Software must write a non-zero
                    digest value via the direct access interface in order to lock the partition.
                    After a reset, write access to the ROT_OWNER_AUTH_SLOT2 partition is locked and
                    the digest becomes visible in this CSR.
                    ''',
          count:     "NumDigestWords",
          swaccess:  "ro",
          hwaccess:  "hwo",
          hwext:     "true",
          cname:     "WORD",
          resval:    0,
          tags: [ // OTP internal HW will update status so can not auto-predict its value.
                  "excl:CsrAllTests:CsrExclCheck"],
          fields: [
            { bits: "31:0"
            }
          ]
        }
      },
      { multireg: {
          name:     "ROT_OWNER_AUTH_SLOT3_DIGEST",
          desc:     '''
                    Integrity digest for the ROT_OWNER_AUTH_SLOT3 partition.
                    The integrity digest is 0 by default. Software must write a non-zero
                    digest value via the direct access interface in order to lock the partition.
                    After a reset, write access to the ROT_OWNER_AUTH_SLOT3 partition is locked and
                    the digest becomes visible in this CSR.
                    ''',
          count:     "NumDigestWords",
          swaccess:  "ro",
          hwaccess:  "hwo",
          hwext:     "true",
          cname:     "WORD",
          resval:    0,
          tags: [ // OTP internal HW will update status so can not auto-predict its value.
                  "excl:CsrAllTests:CsrExclCheck"],
          fields: [
            { bits: "31:0"
            }
          ]
        }
      },
      { multireg: {
          name:     "ROT_OWNER_AUTH_SLOT0_STATE_DIGEST",
          desc:     '''
                    Integrity digest for the ROT_OWNER_AUTH_SLOT0_STATE partition.
                    The integrity digest is 0 by default. Software must write a non-zero
                    digest value via the direct access interface in order to lock the partition.
                    After a reset, write access to the ROT_OWNER_AUTH_SLOT0_STATE partition is locked and
                    the digest becomes visible in this CSR.
                    ''',
          count:     "NumDigestWords",
          swaccess:  "ro",
          hwaccess:  "hwo",
          hwext:     "true",
          cname:     "WORD",
          resval:    0,
          tags: [ // OTP internal HW will update status so can not auto-predict its value.
                  "excl:CsrAllTests:CsrExclCheck"],
          fields: [
            { bits: "31:0"
            }
          ]
        }
      },
      { multireg: {
          name:     "ROT_OWNER_AUTH_SLOT1_STATE_DIGEST",
          desc:     '''
                    Integrity digest for the ROT_OWNER_AUTH_SLOT1_STATE partition.
                    The integrity digest is 0 by default. Software must write a non-zero
                    digest value via the direct access interface in order to lock the partition.
                    After a reset, write access to the ROT_OWNER_AUTH_SLOT1_STATE partition is locked and
                    the digest becomes visible in this CSR.
                    ''',
          count:     "NumDigestWords",
          swaccess:  "ro",
          hwaccess:  "hwo",
          hwext:     "true",
          cname:     "WORD",
          resval:    0,
          tags: [ // OTP internal HW will update status so can not auto-predict its value.
                  "excl:CsrAllTests:CsrExclCheck"],
          fields: [
            { bits: "31:0"
            }
          ]
        }
      },
      { multireg: {
          name:     "ROT_OWNER_AUTH_SLOT2_STATE_DIGEST",
          desc:     '''
                    Integrity digest for the ROT_OWNER_AUTH_SLOT2_STATE partition.
                    The integrity digest is 0 by default. Software must write a non-zero
                    digest value via the direct access interface in order to lock the partition.
                    After a reset, write access to the ROT_OWNER_AUTH_SLOT2_STATE partition is locked and
                    the digest becomes visible in this CSR.
                    ''',
          count:     "NumDigestWords",
          swaccess:  "ro",
          hwaccess:  "hwo",
          hwext:     "true",
          cname:     "WORD",
          resval:    0,
          tags: [ // OTP internal HW will update status so can not auto-predict its value.
                  "excl:CsrAllTests:CsrExclCheck"],
          fields: [
            { bits: "31:0"
            }
          ]
        }
      },
      { multireg: {
          name:     "ROT_OWNER_AUTH_SLOT3_STATE_DIGEST",
          desc:     '''
                    Integrity digest for the ROT_OWNER_AUTH_SLOT3_STATE partition.
                    The integrity digest is 0 by default. Software must write a non-zero
                    digest value via the direct access interface in order to lock the partition.
                    After a reset, write access to the ROT_OWNER_AUTH_SLOT3_STATE partition is locked and
                    the digest becomes visible in this CSR.
                    ''',
          count:     "NumDigestWords",
          swaccess:  "ro",
          hwaccess:  "hwo",
          hwext:     "true",
          cname:     "WORD",
          resval:    0,
          tags: [ // OTP internal HW will update status so can not auto-predict its value.
                  "excl:CsrAllTests:CsrExclCheck"],
          fields: [
            { bits: "31:0"
            }
          ]
        }
      },
      { multireg: {
          name:     "ROM_PATCH_DIGEST",
          desc:     '''
                    Integrity digest for the ROM_PATCH partition.
                    The integrity digest is 0 by default. Software must write a non-zero
                    digest value via the direct access interface in order to lock the partition.
                    After a reset, write access to the ROM_PATCH partition is locked and
                    the digest becomes visible in this CSR.
                    ''',
          count:     "NumDigestWords",
          swaccess:  "ro",
          hwaccess:  "hwo",
          hwext:     "true",
          cname:     "WORD",
          resval:    0,
          tags: [ // OTP internal HW will update status so can not auto-predict its value.
                  "excl:CsrAllTests:CsrExclCheck"],
          fields: [
            { bits: "31:0"
            }
          ]
        }
      },
      { multireg: {
          name:     "SOC_FUSES_CP_DIGEST",
          desc:     '''
                    Integrity digest for the SOC_FUSES_CP partition.
                    The integrity digest is 0 by default. Software must write a non-zero
                    digest value via the direct access interface in order to lock the partition.
                    After a reset, write access to the SOC_FUSES_CP partition is locked and
                    the digest becomes visible in this CSR.
                    ''',
          count:     "NumDigestWords",
          swaccess:  "ro",
          hwaccess:  "hwo",
          hwext:     "true",
          cname:     "WORD",
          resval:    0,
          tags: [ // OTP internal HW will update status so can not auto-predict its value.
                  "excl:CsrAllTests:CsrExclCheck"],
          fields: [
            { bits: "31:0"
            }
          ]
        }
      },
      { multireg: {
          name:     "SOC_FUSES_FT_DIGEST",
          desc:     '''
                    Integrity digest for the SOC_FUSES_FT partition.
                    The integrity digest is 0 by default. Software must write a non-zero
                    digest value via the direct access interface in order to lock the partition.
                    After a reset, write access to the SOC_FUSES_FT partition is locked and
                    the digest becomes visible in this CSR.
                    ''',
          count:     "NumDigestWords",
          swaccess:  "ro",
          hwaccess:  "hwo",
          hwext:     "true",
          cname:     "WORD",
          resval:    0,
          tags: [ // OTP internal HW will update status so can not auto-predict its value.
                  "excl:CsrAllTests:CsrExclCheck"],
          fields: [
            { bits: "31:0"
            }
          ]
        }
      },
      { multireg: {
          name:     "HW_CFG0_DIGEST",
          desc:     '''
                    Integrity digest for the HW_CFG0 partition.
                    The integrity digest is 0 by default. The digest calculation can be triggered via the !!DIRECT_ACCESS_CMD.
                    After a reset, the digest then becomes visible in this CSR, and the corresponding partition becomes write-locked.
                    ''',
          count:     "NumDigestWords",
          swaccess:  "ro",
          hwaccess:  "hwo",
          hwext:     "true",
          cname:     "WORD",
          resval:    0,
          tags: [ // OTP internal HW will update status so can not auto-predict its value.
                  "excl:CsrAllTests:CsrExclCheck"],
          fields: [
            { bits: "31:0"
            }
          ]
        }
      },
      { multireg: {
          name:     "HW_CFG1_DIGEST",
          desc:     '''
                    Integrity digest for the HW_CFG1 partition.
                    The integrity digest is 0 by default. The digest calculation can be triggered via the !!DIRECT_ACCESS_CMD.
                    After a reset, the digest then becomes visible in this CSR, and the corresponding partition becomes write-locked.
                    ''',
          count:     "NumDigestWords",
          swaccess:  "ro",
          hwaccess:  "hwo",
          hwext:     "true",
          cname:     "WORD",
          resval:    0,
          tags: [ // OTP internal HW will update status so can not auto-predict its value.
                  "excl:CsrAllTests:CsrExclCheck"],
          fields: [
            { bits: "31:0"
            }
          ]
        }
      },
      { multireg: {
          name:     "HW_CFG2_DIGEST",
          desc:     '''
                    Integrity digest for the HW_CFG2 partition.
                    The integrity digest is 0 by default. The digest calculation can be triggered via the !!DIRECT_ACCESS_CMD.
                    After a reset, the digest then becomes visible in this CSR, and the corresponding partition becomes write-locked.
                    ''',
          count:     "NumDigestWords",
          swaccess:  "ro",
          hwaccess:  "hwo",
          hwext:     "true",
          cname:     "WORD",
          resval:    0,
          tags: [ // OTP internal HW will update status so can not auto-predict its value.
                  "excl:CsrAllTests:CsrExclCheck"],
          fields: [
            { bits: "31:0"
            }
          ]
        }
      },
      { multireg: {
          name:     "SECRET0_DIGEST",
          desc:     '''
                    Integrity digest for the SECRET0 partition.
                    The integrity digest is 0 by default. The digest calculation can be triggered via the !!DIRECT_ACCESS_CMD.
                    After a reset, the digest then becomes visible in this CSR, and the corresponding partition becomes write-locked.
                    ''',
          count:     "NumDigestWords",
          swaccess:  "ro",
          hwaccess:  "hwo",
          hwext:     "true",
          cname:     "WORD",
          resval:    0,
          tags: [ // OTP internal HW will update status so can not auto-predict its value.
                  "excl:CsrAllTests:CsrExclCheck"],
          fields: [
            { bits: "31:0"
            }
          ]
        }
      },
      { multireg: {
          name:     "SECRET1_DIGEST",
          desc:     '''
                    Integrity digest for the SECRET1 partition.
                    The integrity digest is 0 by default. The digest calculation can be triggered via the !!DIRECT_ACCESS_CMD.
                    After a reset, the digest then becomes visible in this CSR, and the corresponding partition becomes write-locked.
                    ''',
          count:     "NumDigestWords",
          swaccess:  "ro",
          hwaccess:  "hwo",
          hwext:     "true",
          cname:     "WORD",
          resval:    0,
          tags: [ // OTP internal HW will update status so can not auto-predict its value.
                  "excl:CsrAllTests:CsrExclCheck"],
          fields: [
            { bits: "31:0"
            }
          ]
        }
      },
      { multireg: {
          name:     "SECRET2_DIGEST",
          desc:     '''
                    Integrity digest for the SECRET2 partition.
                    The integrity digest is 0 by default. The digest calculation can be triggered via the !!DIRECT_ACCESS_CMD.
                    After a reset, the digest then becomes visible in this CSR, and the corresponding partition becomes write-locked.
                    ''',
          count:     "NumDigestWords",
          swaccess:  "ro",
          hwaccess:  "hwo",
          hwext:     "true",
          cname:     "WORD",
          resval:    0,
          tags: [ // OTP internal HW will update status so can not auto-predict its value.
                  "excl:CsrAllTests:CsrExclCheck"],
          fields: [
            { bits: "31:0"
            }
          ]
        }
      },
      { multireg: {
          name:     "SECRET3_DIGEST",
          desc:     '''
                    Integrity digest for the SECRET3 partition.
                    The integrity digest is 0 by default. The digest calculation can be triggered via the !!DIRECT_ACCESS_CMD.
                    After a reset, the digest then becomes visible in this CSR, and the corresponding partition becomes write-locked.
                    ''',
          count:     "NumDigestWords",
          swaccess:  "ro",
          hwaccess:  "hwo",
          hwext:     "true",
          cname:     "WORD",
          resval:    0,
          tags: [ // OTP internal HW will update status so can not auto-predict its value.
                  "excl:CsrAllTests:CsrExclCheck"],
          fields: [
            { bits: "31:0"
            }
          ]
        }
      },

      ////////////////////////////////
      // Software Config Partitions //
      ////////////////////////////////
      { skipto: "0x8000" }

      { window: {
          name: "SW_CFG_WINDOW"
          items: "NumSwCfgWindowWords"
          swaccess: "ro",
          desc: '''
          Any read to this window directly maps to the corresponding offset in the creator and owner software
          config partitions, and triggers an OTP readout of the bytes requested. Note that the transaction
          will block until OTP readout has completed.
          '''
        }
      }
    ],
  }
}
