// Copyright lowRISC contributors (OpenTitan project).
// Licensed under the Apache License, Version 2.0, see LICENSE for details.
// SPDX-License-Identifier: Apache-2.0
//
// ------------------- W A R N I N G: A U T O - G E N E R A T E D   C O D E !! -------------------//
// PLEASE DO NOT HAND-EDIT THIS FILE. IT HAS BEEN AUTO-GENERATED WITH THE FOLLOWING COMMAND:
// util/topgen.py -t hw/top_dragonfly/data/top_dragonfly.hjson
//                -o hw/top_dragonfly/
{
  seed:
  {
    topgen_seed:
    {
      seed_mode: testing
      value: 30303603493614338660957087945302489777030192937656386903877022866265637632015
    }
    otp_img_seed:
    {
      seed_mode: testing
      value: 85452983286950371191603618368782861611109037138182535346147818831008789508651
    }
    lc_ctrl_seed:
    {
      seed_mode: testing
      value: 73183785937994765942105269559576336430731269166614113490738802526276329963158
    }
  }
  module:
  [
    {
      name: otp_ctrl
      type: otp_ctrl
      base_addrs:
      {
        core:
        {
          hart: 0x30130000
        }
      }
      memory: {}
      param_list:
      [
        {
          name: RndCnstLfsrSeed
          desc: Compile-time random bits for initial LFSR seed
          type: otp_ctrl_top_specific_pkg::lfsr_seed_t
          randcount: 40
          randtype: data
          name_top: RndCnstOtpCtrlLfsrSeed
          default: 0xcd45c60d14
          randwidth: 40
        }
        {
          name: RndCnstLfsrPerm
          desc: Compile-time random permutation for LFSR output
          type: otp_ctrl_top_specific_pkg::lfsr_perm_t
          randcount: 40
          randtype: perm
          name_top: RndCnstOtpCtrlLfsrPerm
          default: 0x120437874c290f5a29e07dc38a19724b64815b85151534c6988e5126750
          randwidth: 240
        }
        {
          name: RndCnstScrmblKeyInit
          desc: Compile-time random permutation for scrambling key/nonce register reset value
          type: otp_ctrl_top_specific_pkg::scrmbl_key_init_t
          randcount: 256
          randtype: data
          name_top: RndCnstOtpCtrlScrmblKeyInit
          default: 0x5f3d22f5ca036e029dfe3e013f88514b08e645bba939b14566456ba439fb382d
          randwidth: 256
        }
        {
          name: RndCnstScrmblKey0
          desc: Compile-time scrambling key
          type: otp_ctrl_top_specific_pkg::key_t
          randcount: 128
          randtype: extdata
          name_top: RndCnstOtpCtrlScrmblKey0
          default: 0x688a9a20b68e0d35660e593f560f6866
          randwidth: 128
        }
        {
          name: RndCnstScrmblKey1
          desc: Compile-time scrambling key
          type: otp_ctrl_top_specific_pkg::key_t
          randcount: 128
          randtype: extdata
          name_top: RndCnstOtpCtrlScrmblKey1
          default: 0xa1ad90a50942397740ab78c5737a2379
          randwidth: 128
        }
        {
          name: RndCnstScrmblKey2
          desc: Compile-time scrambling key
          type: otp_ctrl_top_specific_pkg::key_t
          randcount: 128
          randtype: extdata
          name_top: RndCnstOtpCtrlScrmblKey2
          default: 0xc2ede5b25ec5514b680ccaab361c3f85
          randwidth: 128
        }
        {
          name: RndCnstScrmblKey3
          desc: Compile-time scrambling key
          type: otp_ctrl_top_specific_pkg::key_t
          randcount: 128
          randtype: extdata
          name_top: RndCnstOtpCtrlScrmblKey3
          default: 0x8e1c5cccc121a2c95d21294d190ab75c
          randwidth: 128
        }
        {
          name: RndCnstDigestConst0
          desc: Compile-time digest const
          type: otp_ctrl_top_specific_pkg::digest_const_t
          randcount: 128
          randtype: extdata
          name_top: RndCnstOtpCtrlDigestConst0
          default: 0x9c87e42745452d8a010a9f0ef3221d5
          randwidth: 128
        }
        {
          name: RndCnstDigestConst1
          desc: Compile-time digest const
          type: otp_ctrl_top_specific_pkg::digest_const_t
          randcount: 128
          randtype: extdata
          name_top: RndCnstOtpCtrlDigestConst1
          default: 0x4dcba329ff2f7d4b8a3acdb325087fab
          randwidth: 128
        }
        {
          name: RndCnstDigestIV0
          desc: Compile-time digest initial vector
          type: otp_ctrl_top_specific_pkg::digest_iv_t
          randcount: 64
          randtype: extdata
          name_top: RndCnstOtpCtrlDigestIV0
          default: 0xa0806e02a1fba55b
          randwidth: 64
        }
        {
          name: RndCnstDigestIV1
          desc: Compile-time digest initial vector
          type: otp_ctrl_top_specific_pkg::digest_iv_t
          randcount: 64
          randtype: extdata
          name_top: RndCnstOtpCtrlDigestIV1
          default: 0x9bd623e40aec9b61
          randwidth: 64
        }
        {
          name: RndCnstPartInvDefault
          desc: OTP invalid partition default for buffered partitions
          type: logic [163839:0]
          randcount: 163840
          randtype: extdata
          name_top: RndCnstOtpCtrlPartInvDefault
          default:
          [
            {
              size: 704
              items:
              [
                {
                  size: 320
                  inv_default: 1740163610035578858103898302773429044443128827890610586479008287934284440493394280935669489663884
                }
                {
                  size: 384
                  inv_default: 14973992796729436808066378999705846639531905052544376352002892737561959261552710366946253675634166805643724298065935
                }
              ]
            }
            {
              size: 384
              items:
              [
                {
                  size: 64
                  inv_default: 0
                }
                {
                  size: 64
                  inv_default: 17482466783658110580
                }
                {
                  size: 256
                  inv_default: 70686486377297932620694155829978992075095653265301635643322899792586608109306
                }
              ]
            }
            {
              size: 1024
              items:
              [
                {
                  size: 64
                  inv_default: 0
                }
                {
                  size: 64
                  inv_default: 1794854062480160716
                }
                {
                  size: 256
                  inv_default: 17833865895625802678504757898438306129490488436729400947978243968268591742052
                }
                {
                  size: 256
                  inv_default: 1304928998077618167994330237584170289335028615580548538480488972898025704836
                }
                {
                  size: 256
                  inv_default: 34629914360704372211018394036838819133727768471239971144446686782216090585462
                }
                {
                  size: 128
                  inv_default: 318948098383762964490193881142352172697
                }
              ]
            }
            {
              size: 256
              items:
              [
                {
                  size: 64
                  inv_default: 0
                }
                {
                  size: 64
                  inv_default: 5791744465669227273
                }
                {
                  size: 128
                  inv_default: 49610584572420053792236730456054518552
                }
              ]
            }
            {
              size: 384
              items:
              [
                {
                  size: 64
                  inv_default: 0
                }
                {
                  size: 64
                  inv_default: 13418438502867544032
                }
                {
                  size: 128
                  inv_default: 241193388044955693821746483131132302114
                }
                {
                  size: 128
                  inv_default: 42146219275086284332081154515457931983
                }
              ]
            }
            {
              size: 448
              items:
              [
                {
                  size: 64
                  inv_default: 0
                }
                {
                  size: 64
                  inv_default: 6520999107440904866
                }
                {
                  comment: unallocated space
                  size: 32
                  inv_default: 0
                }
                {
                  size: 256
                  inv_default: 104735823630885006896435419055152518946049592294862500793111622154345667968901
                }
                {
                  size: 32
                  inv_default: 0
                }
              ]
            }
            {
              size: 192
              items:
              [
                {
                  size: 64
                  inv_default: 0
                }
                {
                  size: 64
                  inv_default: 9694113004490520906
                }
                {
                  comment: unallocated space
                  size: 48
                  inv_default: 0
                }
                {
                  size: 8
                  inv_default: 105
                }
                {
                  size: 8
                  inv_default: 105
                }
              ]
            }
            {
              size: 384
              items:
              [
                {
                  size: 64
                  inv_default: 0
                }
                {
                  size: 64
                  inv_default: 15994060125354592494
                }
                {
                  size: 256
                  inv_default: 40117173308102545085356168480633505499540504862520500713288653871548071919464
                }
              ]
            }
            {
              size: 19200
              items:
              [
                {
                  size: 64
                  inv_default: 0
                }
                {
                  size: 19136
                  inv_default: 0
                }
              ]
            }
            {
              size: 33856
              items:
              [
                {
                  size: 64
                  inv_default: 2245725931179433842
                }
                {
                  size: 30720
                  inv_default: 0
                }
                {
                  size: 3072
                  inv_default: 0
                }
              ]
            }
            {
              size: 3136
              items:
              [
                {
                  size: 64
                  inv_default: 8050338520295093693
                }
                {
                  size: 1024
                  inv_default: 0
                }
                {
                  size: 2048
                  inv_default: 0
                }
              ]
            }
            {
              size: 65664
              items:
              [
                {
                  size: 64
                  inv_default: 0
                }
                {
                  size: 64
                  inv_default: 14592557388175589354
                }
                {
                  size: 65536
                  inv_default: 0
                }
              ]
            }
            {
              size: 8256
              items:
              [
                {
                  size: 64
                  inv_default: 0
                }
                {
                  size: 8192
                  inv_default: 0
                }
              ]
            }
            {
              size: 1280
              items:
              [
                {
                  size: 64
                  inv_default: 0
                }
                {
                  size: 64
                  inv_default: 2932316366930412108
                }
                {
                  size: 512
                  inv_default: 0
                }
                {
                  size: 32
                  inv_default: 0
                }
                {
                  size: 32
                  inv_default: 0
                }
                {
                  size: 512
                  inv_default: 0
                }
                {
                  size: 32
                  inv_default: 0
                }
                {
                  size: 32
                  inv_default: 0
                }
              ]
            }
            {
              size: 1280
              items:
              [
                {
                  size: 64
                  inv_default: 0
                }
                {
                  size: 64
                  inv_default: 16981414814768445627
                }
                {
                  size: 512
                  inv_default: 0
                }
                {
                  size: 32
                  inv_default: 0
                }
                {
                  size: 32
                  inv_default: 0
                }
                {
                  size: 512
                  inv_default: 0
                }
                {
                  size: 32
                  inv_default: 0
                }
                {
                  size: 32
                  inv_default: 0
                }
              ]
            }
            {
              size: 1280
              items:
              [
                {
                  size: 64
                  inv_default: 0
                }
                {
                  size: 64
                  inv_default: 9966431396093675977
                }
                {
                  size: 512
                  inv_default: 0
                }
                {
                  size: 32
                  inv_default: 0
                }
                {
                  size: 32
                  inv_default: 0
                }
                {
                  size: 512
                  inv_default: 0
                }
                {
                  size: 32
                  inv_default: 0
                }
                {
                  size: 32
                  inv_default: 0
                }
              ]
            }
            {
              size: 1280
              items:
              [
                {
                  size: 64
                  inv_default: 0
                }
                {
                  size: 64
                  inv_default: 13089428196878425884
                }
                {
                  size: 512
                  inv_default: 0
                }
                {
                  size: 32
                  inv_default: 0
                }
                {
                  size: 32
                  inv_default: 0
                }
                {
                  size: 512
                  inv_default: 0
                }
                {
                  size: 32
                  inv_default: 0
                }
                {
                  size: 32
                  inv_default: 0
                }
              ]
            }
            {
              size: 1280
              items:
              [
                {
                  size: 64
                  inv_default: 0
                }
                {
                  size: 64
                  inv_default: 13047861355720130167
                }
                {
                  size: 512
                  inv_default: 0
                }
                {
                  size: 32
                  inv_default: 0
                }
                {
                  size: 32
                  inv_default: 0
                }
                {
                  size: 512
                  inv_default: 0
                }
                {
                  size: 32
                  inv_default: 0
                }
                {
                  size: 32
                  inv_default: 0
                }
              ]
            }
            {
              size: 1280
              items:
              [
                {
                  size: 64
                  inv_default: 0
                }
                {
                  size: 64
                  inv_default: 18297828617386945793
                }
                {
                  size: 512
                  inv_default: 0
                }
                {
                  size: 32
                  inv_default: 0
                }
                {
                  size: 32
                  inv_default: 0
                }
                {
                  size: 512
                  inv_default: 0
                }
                {
                  size: 32
                  inv_default: 0
                }
                {
                  size: 32
                  inv_default: 0
                }
              ]
            }
            {
              size: 2432
              items:
              [
                {
                  size: 64
                  inv_default: 0
                }
                {
                  size: 64
                  inv_default: 5471265045120329804
                }
                {
                  size: 512
                  inv_default: 0
                }
                {
                  size: 32
                  inv_default: 0
                }
                {
                  size: 32
                  inv_default: 0
                }
                {
                  size: 512
                  inv_default: 0
                }
                {
                  size: 32
                  inv_default: 0
                }
                {
                  size: 32
                  inv_default: 0
                }
                {
                  size: 512
                  inv_default: 0
                }
                {
                  size: 32
                  inv_default: 0
                }
                {
                  size: 32
                  inv_default: 0
                }
                {
                  size: 512
                  inv_default: 0
                }
                {
                  size: 32
                  inv_default: 0
                }
                {
                  size: 32
                  inv_default: 0
                }
              ]
            }
            {
              size: 2880
              items:
              [
                {
                  size: 64
                  inv_default: 0
                }
                {
                  size: 64
                  inv_default: 18001735645508761512
                }
                {
                  size: 512
                  inv_default: 0
                }
                {
                  size: 512
                  inv_default: 0
                }
                {
                  size: 512
                  inv_default: 0
                }
                {
                  size: 32
                  inv_default: 0
                }
                {
                  size: 32
                  inv_default: 0
                }
                {
                  size: 512
                  inv_default: 0
                }
                {
                  size: 32
                  inv_default: 0
                }
                {
                  size: 32
                  inv_default: 0
                }
                {
                  size: 512
                  inv_default: 0
                }
                {
                  size: 32
                  inv_default: 0
                }
                {
                  size: 32
                  inv_default: 0
                }
              ]
            }
            {
              size: 6400
              items:
              [
                {
                  size: 64
                  inv_default: 0
                }
                {
                  size: 64
                  inv_default: 13936327800626111575
                }
                {
                  size: 128
                  inv_default: 0
                }
                {
                  size: 6144
                  inv_default: 0
                }
              ]
            }
            {
              size: 448
              items:
              [
                {
                  size: 64
                  inv_default: 0
                }
                {
                  size: 128
                  inv_default: 0
                }
                {
                  size: 128
                  inv_default: 0
                }
                {
                  size: 128
                  inv_default: 0
                }
              ]
            }
            {
              size: 7744
              items:
              [
                {
                  size: 64
                  inv_default: 0
                }
                {
                  size: 64
                  inv_default: 3036799796741757437
                }
                {
                  size: 32
                  inv_default: 0
                }
                {
                  size: 32
                  inv_default: 0
                }
                {
                  size: 32
                  inv_default: 0
                }
                {
                  size: 32
                  inv_default: 0
                }
                {
                  size: 32
                  inv_default: 0
                }
                {
                  size: 32
                  inv_default: 0
                }
                {
                  size: 32
                  inv_default: 0
                }
                {
                  size: 512
                  inv_default: 0
                }
                {
                  size: 128
                  inv_default: 0
                }
                {
                  size: 128
                  inv_default: 0
                }
                {
                  size: 224
                  inv_default: 0
                }
                {
                  size: 6304
                  inv_default: 0
                }
                {
                  size: 32
                  inv_default: 0
                }
                {
                  size: 32
                  inv_default: 0
                }
                {
                  size: 32
                  inv_default: 0
                }
              ]
            }
            {
              size: 1792
              items:
              [
                {
                  size: 64
                  inv_default: 0
                }
                {
                  size: 64
                  inv_default: 10745993536467849044
                }
                {
                  size: 32
                  inv_default: 0
                }
                {
                  size: 32
                  inv_default: 0
                }
                {
                  size: 32
                  inv_default: 0
                }
                {
                  size: 32
                  inv_default: 0
                }
                {
                  size: 32
                  inv_default: 0
                }
                {
                  size: 32
                  inv_default: 0
                }
                {
                  size: 32
                  inv_default: 0
                }
                {
                  size: 32
                  inv_default: 0
                }
                {
                  size: 32
                  inv_default: 0
                }
                {
                  size: 32
                  inv_default: 0
                }
                {
                  size: 32
                  inv_default: 0
                }
                {
                  size: 32
                  inv_default: 0
                }
                {
                  size: 32
                  inv_default: 0
                }
                {
                  size: 32
                  inv_default: 0
                }
                {
                  size: 32
                  inv_default: 0
                }
                {
                  size: 32
                  inv_default: 0
                }
                {
                  size: 32
                  inv_default: 0
                }
                {
                  size: 32
                  inv_default: 1768515945
                }
                {
                  size: 32
                  inv_default: 1768515945
                }
                {
                  size: 32
                  inv_default: 1768515945
                }
                {
                  size: 32
                  inv_default: 0
                }
                {
                  size: 992
                  inv_default: 0
                }
              ]
            }
            {
              size: 576
              items:
              [
                {
                  size: 64
                  inv_default: 0
                }
                {
                  size: 64
                  inv_default: 312179291205032755
                }
                {
                  size: 448
                  inv_default: 0
                }
              ]
            }
          ]
          randwidth: 163840
        }
      ]
      template_type: otp_ctrl
      otp_mmap:
      {
        otp:
        {
          width: 2
          depth: 10240
          size: 20480
          addr_width: 14
          byte_addr_width: 15
        }
        scrambling:
        {
          key_size: 16
          iv_size: 8
          cnst_size: 16
          keys:
          [
            {
              name: Secret0Key
              value: 138959374610987221438102940065509369958
            }
            {
              name: Secret1Key
              value: 214906908420393146978604154423181190009
            }
            {
              name: Secret2Key
              value: 259105464341488730475238499589165956997
            }
            {
              name: Secret3Key
              value: 188897641917496988174986683742771918684
            }
          ]
          digests:
          [
            {
              name: CnstyDigest
              iv_value: 11565364800674047323
              cnst_value: 13004072182442196571965938888816599509
            }
            {
              name: SramDataKey
              iv_value: 11229202183237704545
              cnst_value: 103407901297817239236543323158765666219
            }
          ]
          num_keys: 4
          num_digests: 2
        }
        partitions:
        [
          {
            name: VENDOR_TEST
            variant: Unbuffered
            absorb: false
            secret: false
            sw_digest: true
            hw_digest: false
            write_lock: Digest
            read_lock: CSR
            key_sel: NoKey
            integrity: false
            bkout_type: false
            zeroizable: true
            skip_sw_header: true
            items:
            [
              {
                name: SCRATCH
                size: 56
                isdigest: false
                iszer: false
                ismubi: false
                iskeymgr_creator: false
                iskeymgr_owner: false
                absorb: false
                inv_default: 0
                offset: 0
              }
              {
                name: VENDOR_TEST_DIGEST
                size: 8
                offset: 56
                ismubi: false
                isdigest: true
                iszer: false
                inv_default: 312179291205032755
                iskeymgr_creator: false
                iskeymgr_owner: false
              }
              {
                name: VENDOR_TEST_ZER
                size: 8
                offset: 64
                ismubi: false
                isdigest: false
                iszer: true
                inv_default: 0
                iskeymgr_creator: false
                iskeymgr_owner: false
              }
            ]
            desc:
              '''
              Vendor test partition.
              This is reserved for manufacturing smoke checks. The OTP wrapper
              control logic inside prim_otp is allowed to read/write to this
              region. ECC uncorrectable errors seen on the functional prim_otp
              interface will not lead to an alert for this partition.
              Instead, such errors will be reported as correctable ECC errors.
              '''
            iskeymgr_creator: false
            iskeymgr_owner: false
            ignore_read_lock_in_rma: false
            size: 72
            offset: 0
          }
          {
            name: CREATOR_SW_CFG
            variant: Unbuffered
            absorb: false
            secret: false
            sw_digest: true
            hw_digest: false
            write_lock: Digest
            read_lock: CSR
            key_sel: NoKey
            integrity: true
            bkout_type: false
            zeroizable: true
            items:
            [
              {
                name: CREATOR_SW_CFG_AST_CFG
                size: 124
                desc:
                  '''
                  AST configuration data. These values get blindly copied to
                  the AST CSRs during ROM execution.
                  '''
                isdigest: false
                iszer: false
                ismubi: false
                iskeymgr_creator: false
                iskeymgr_owner: false
                absorb: false
                inv_default: 0
                offset: 72
              }
              {
                name: CREATOR_SW_CFG_AST_INIT_SIZE
                size: 4
                desc:
                  '''
                  Controls how many 32-bit words from the CREATOR_SW_CFG_AST_CFG item
                  get copied to the AST CSRs during ROM execution.
                  '''
                isdigest: false
                iszer: false
                ismubi: false
                iskeymgr_creator: false
                iskeymgr_owner: false
                absorb: false
                inv_default: 0
                offset: 196
              }
              {
                name: CREATOR_SW_CFG_ROM_SECURE_BOOT_EN
                size: 4
                ismubi: true
                inv_default: 1768515945
                desc:
                  '''
                  Secure boot chicken bit. Secure boot is enabled iff this is
                  set to kMultiBitBool32True. ACC is not loaded with any code
                  for any other values.
                  '''
                isdigest: false
                iszer: false
                iskeymgr_creator: false
                iskeymgr_owner: false
                absorb: false
                offset: 200
              }
              {
                name: CREATOR_SW_CFG_ROM_SIGGEN_EN
                size: 4
                ismubi: true
                inv_default: 1768515945
                desc:
                  '''
                  Signature generation chicken bit. Asset signatures are
                  generated iff both this item and
                  CREATOR_SW_CFG_ROM_SECURE_BOOT_EN are set to
                  kMultiBitBool32True.
                  '''
                isdigest: false
                iszer: false
                iskeymgr_creator: false
                iskeymgr_owner: false
                absorb: false
                offset: 204
              }
              {
                name: CREATOR_SW_CFG_ROM_SIGVERIFY_EN
                size: 4
                ismubi: true
                inv_default: 1768515945
                desc:
                  '''
                  Signature verification chicken bit. Asset signatures are
                  verified iff this item, the CREATOR_SW_CFG_ROM_SECURE_BOOT_EN
                  and the CREATOR_SW_CFG_ROM_SIGGEN_EN ones are all set to
                  kMultiBitBool32True.
                  '''
                isdigest: false
                iszer: false
                iskeymgr_creator: false
                iskeymgr_owner: false
                absorb: false
                offset: 208
              }
              {
                name: CREATOR_SW_CFG_SIGVERIFY_SPX_EN
                size: 4
                desc:
                  '''
                  Controls whether or not SPHINCS+ signature verification will
                  be executed when the ROM attempts to boot the ROM_EXT.
                  A value of kSigverifySpxDisabledOtp disables SPHINCS+
                  signature verification, while all other values enable it.
                  Note, SPHINCS+ signature verification is always disabled in
                  TEST_UNLOCKED* LC states.
                  '''
                isdigest: false
                iszer: false
                ismubi: false
                iskeymgr_creator: false
                iskeymgr_owner: false
                absorb: false
                inv_default: 0
                offset: 212
              }
              {
                name: CREATOR_SW_CFG_RNG_EN
                size: 4
                desc:
                  '''
                  Whether or not to enable use of hardware generated entropy
                  (from the entropy complex via EDN) in the `rnd_uint32`
                  function. A value of kHardenedBoolTrue enables the use of
                  hardware generated entropy, while all other values disable.
                  '''
                isdigest: false
                iszer: false
                ismubi: false
                iskeymgr_creator: false
                iskeymgr_owner: false
                absorb: false
                inv_default: 0
                offset: 216
              }
              {
                name: CREATOR_SW_CFG_JITTER_EN
                size: 4
                desc:
                  '''
                  Whether or not to enable clock jitter. A value of
                  kMultiBitBool4False disables, while all other values enable.
                  '''
                isdigest: false
                iszer: false
                ismubi: false
                iskeymgr_creator: false
                iskeymgr_owner: false
                absorb: false
                inv_default: 0
                offset: 220
              }
              {
                name: CREATOR_SW_CFG_RET_RAM_RESET_MASK
                size: 4
                desc:
                  '''
                  Reset reason mask used to initialize (by overwriting with
                  random data) retention SRAM during ROM execution. A value of
                  0 only initializes retention SRAM on power-on-resets.See
                  rstmgr RESET_INFO CSR documentation for more details.
                  '''
                isdigest: false
                iszer: false
                ismubi: false
                iskeymgr_creator: false
                iskeymgr_owner: false
                absorb: false
                inv_default: 0
                offset: 224
              }
              {
                name: CREATOR_SW_CFG_CPUCTRL
                size: 4
                desc:
                  '''
                  Value to write to the Ibex CPUCTRL CSR during ROM execution.
                  This field controls settings such as ICACHE enablement. See
                  Ibex documentation for more information.
                  '''
                isdigest: false
                iszer: false
                ismubi: false
                iskeymgr_creator: false
                iskeymgr_owner: false
                absorb: false
                inv_default: 0
                offset: 228
              }
              {
                name: CREATOR_SW_CFG_RNG_REPCNT_THRESHOLDS
                size: 4
                isdigest: false
                iszer: false
                ismubi: false
                iskeymgr_creator: false
                iskeymgr_owner: false
                absorb: false
                inv_default: 0
                offset: 232
              }
              {
                name: CREATOR_SW_CFG_RNG_REPCNTS_THRESHOLDS
                size: 4
                isdigest: false
                iszer: false
                ismubi: false
                iskeymgr_creator: false
                iskeymgr_owner: false
                absorb: false
                inv_default: 0
                offset: 236
              }
              {
                name: CREATOR_SW_CFG_RNG_ADAPTP_HI_THRESHOLDS
                size: 4
                isdigest: false
                iszer: false
                ismubi: false
                iskeymgr_creator: false
                iskeymgr_owner: false
                absorb: false
                inv_default: 0
                offset: 240
              }
              {
                name: CREATOR_SW_CFG_RNG_ADAPTP_LO_THRESHOLDS
                size: 4
                isdigest: false
                iszer: false
                ismubi: false
                iskeymgr_creator: false
                iskeymgr_owner: false
                absorb: false
                inv_default: 0
                offset: 244
              }
              {
                name: CREATOR_SW_CFG_RNG_BUCKET_THRESHOLDS
                size: 4
                isdigest: false
                iszer: false
                ismubi: false
                iskeymgr_creator: false
                iskeymgr_owner: false
                absorb: false
                inv_default: 0
                offset: 248
              }
              {
                name: CREATOR_SW_CFG_RNG_MARKOV_HI_THRESHOLDS
                size: 4
                isdigest: false
                iszer: false
                ismubi: false
                iskeymgr_creator: false
                iskeymgr_owner: false
                absorb: false
                inv_default: 0
                offset: 252
              }
              {
                name: CREATOR_SW_CFG_RNG_MARKOV_LO_THRESHOLDS
                size: 4
                isdigest: false
                iszer: false
                ismubi: false
                iskeymgr_creator: false
                iskeymgr_owner: false
                absorb: false
                inv_default: 0
                offset: 256
              }
              {
                name: CREATOR_SW_CFG_RNG_EXTHT_HI_THRESHOLDS
                size: 4
                isdigest: false
                iszer: false
                ismubi: false
                iskeymgr_creator: false
                iskeymgr_owner: false
                absorb: false
                inv_default: 0
                offset: 260
              }
              {
                name: CREATOR_SW_CFG_RNG_EXTHT_LO_THRESHOLDS
                size: 4
                isdigest: false
                iszer: false
                ismubi: false
                iskeymgr_creator: false
                iskeymgr_owner: false
                absorb: false
                inv_default: 0
                offset: 264
              }
              {
                name: CREATOR_SW_CFG_RNG_ALERT_THRESHOLD
                size: 4
                isdigest: false
                iszer: false
                ismubi: false
                iskeymgr_creator: false
                iskeymgr_owner: false
                absorb: false
                inv_default: 0
                offset: 268
              }
              {
                name: CREATOR_SW_CFG_RNG_HEALTH_CONFIG_DIGEST
                size: 4
                isdigest: false
                iszer: false
                ismubi: false
                iskeymgr_creator: false
                iskeymgr_owner: false
                absorb: false
                inv_default: 0
                offset: 272
              }
              {
                name: CREATOR_SW_CFG_SRAM_KEY_RENEW_AND_INIT_EN
                size: 4
                desc:
                  '''
                  Whether or not the ROM should request SRAM to be rescrambled
                  with a new key on every boot. This includes renewing the
                  scrambling key and then initializing SRAM with pseudo-random
                  data. kHardenedBoolFalse disables, while all other values
                  enable.
                  '''
                isdigest: false
                iszer: false
                ismubi: false
                iskeymgr_creator: false
                iskeymgr_owner: false
                absorb: false
                inv_default: 0
                offset: 276
              }
              {
                name: CREATOR_SW_CFG_DIGEST
                size: 8
                offset: 280
                ismubi: false
                isdigest: true
                iszer: false
                inv_default: 10745993536467849044
                iskeymgr_creator: false
                iskeymgr_owner: false
              }
              {
                name: CREATOR_SW_CFG_ZER
                size: 8
                offset: 288
                ismubi: false
                isdigest: false
                iszer: true
                inv_default: 0
                iskeymgr_creator: false
                iskeymgr_owner: false
              }
            ]
            desc:
              '''
              Software configuration partition.
              This is for device-specific calibration data. For example, clock,
              LDO, RNG.
              '''
            iskeymgr_creator: false
            iskeymgr_owner: false
            ignore_read_lock_in_rma: false
            size: 224
            offset: 72
          }
          {
            name: OWNER_SW_CFG
            variant: Unbuffered
            absorb: false
            secret: false
            sw_digest: true
            hw_digest: false
            write_lock: Digest
            read_lock: CSR
            key_sel: NoKey
            integrity: true
            bkout_type: false
            zeroizable: true
            items:
            [
              {
                name: OWNER_SW_CFG_ROM_ERROR_REPORTING
                size: 4
                desc:
                  '''
                  The shutdown error reporting verbosity used by the ROM.
                  Should be configured to one of several
                  `shutdown_error_redact_t` values. See
                  `sw/device/silicon_creator/lib/shutdown.h` for more details.
                  '''
                isdigest: false
                iszer: false
                ismubi: false
                iskeymgr_creator: false
                iskeymgr_owner: false
                absorb: false
                inv_default: 0
                offset: 296
              }
              {
                name: OWNER_SW_CFG_ROM_ALERT_CLASS_EN
                size: 4
                desc:
                  '''
                  A four byte packed field, where each byte controls whether
                  or not the ROM enables each alert class (A through D) of the
                  alert_handler. The byte-sized sub-fields are arranged from D
                  to A, MSB to LSB. Each byte should be set to an
                  `alert_enable_t` value accordingly. See the alert_handler
                  documentation for more details.
                  '''
                isdigest: false
                iszer: false
                ismubi: false
                iskeymgr_creator: false
                iskeymgr_owner: false
                absorb: false
                inv_default: 0
                offset: 300
              }
              {
                name: OWNER_SW_CFG_ROM_ALERT_ESCALATION
                size: 4
                desc:
                  '''
                  A four byte packed field, where each byte controls the
                  escalation configuration for each alert class (A through D)
                  of the alert_handler configured by the ROM. The byte-sized
                  sub-fields are arranged from D to A, MSB to LSB. Each byte
                  should be set to an `alert_escalate_t` value accordingly.
                  See the alert_handler documentation for more details.
                  '''
                isdigest: false
                iszer: false
                ismubi: false
                iskeymgr_creator: false
                iskeymgr_owner: false
                absorb: false
                inv_default: 0
                offset: 304
              }
              {
                name: OWNER_SW_CFG_ROM_ALERT_CLASSIFICATION
                size: 788
                desc:
                  '''
                  The alert classifications (A through D) for each alert
                  source of the alert_handler to be configured by the ROM. The
                  field consists of a contiguous 320-byte block, or 80 32-bit
                  words. The four bytes in each word encode the configuration
                  of a single alert source across four lifecycle states, in
                  order from LSB to MSB: PROD, PROD_END, DEV, and RMA. Each
                  byte should be set to an `alert_class_t` value accordingly.
                  The order of the 197 32-bit words, from LSB to MSB can be
                  found in the DRAGONFLY_ALERTS list in
                  `hw/top_dragonfly/data/autogen/defs.bzl`.
                  See the alert_handler documentation for more details.
                  '''
                isdigest: false
                iszer: false
                ismubi: false
                iskeymgr_creator: false
                iskeymgr_owner: false
                absorb: false
                inv_default: 0
                offset: 308
              }
              {
                name: OWNER_SW_CFG_ROM_LOCAL_ALERT_CLASSIFICATION
                size: 28
                desc:
                  '''
                  Same as the `OWNER_SW_CFG_ROM_ALERT_CLASSIFICATION` field,
                  except these configuration correspond to the local alert
                  sources found in the `DRAGONFLY_LOC_ALERTS list in
                  `rules/const.bzl`.
                  '''
                isdigest: false
                iszer: false
                ismubi: false
                iskeymgr_creator: false
                iskeymgr_owner: false
                absorb: false
                inv_default: 0
                offset: 1096
              }
              {
                name: OWNER_SW_CFG_ROM_ALERT_ACCUM_THRESH
                size: 16
                desc:
                  '''
                  The alert accumulation threshold values for each alert class
                  (A through D) of the alert_handler to be configured by the
                  ROM. This field consists of four 32-bit words encoding the
                  accumulation thresholds for each alert class A through D
                  arranged LSW to MSW. See the alert_handler documentation for
                  more details.
                  '''
                isdigest: false
                iszer: false
                ismubi: false
                iskeymgr_creator: false
                iskeymgr_owner: false
                absorb: false
                inv_default: 0
                offset: 1124
              }
              {
                name: OWNER_SW_CFG_ROM_ALERT_TIMEOUT_CYCLES
                size: 16
                desc:
                  '''
                  Same as the `OWNER_SW_CFG_ROM_ALERT_ACCUM_THRESH` field,
                  except each value corresponds to the interrupt timeout
                  configuration of an alert class.
                  '''
                isdigest: false
                iszer: false
                ismubi: false
                iskeymgr_creator: false
                iskeymgr_owner: false
                absorb: false
                inv_default: 0
                offset: 1140
              }
              {
                name: OWNER_SW_CFG_ROM_ALERT_PHASE_CYCLES
                size: 64
                desc:
                  '''
                  The alert escalation phase durations, measured in clock
                  cycles, the ROM will configure the four alert phases for
                  each alert class of the alert_handler. This field consists
                  of a contiguous 64-byte block, or an array of four 128-bit
                  fields. Each 128-bit sub-field encodes four 32-bit words that
                  contain the alert phase cycle count configurations for alert
                  escalation phases 0 to 3, from LSW to MSW. Each 128-bit
                  sub-field is contains all configurations for a single alert
                  class, arranged from class A to D, from LS to MS. For
                  example, the cycle durations of each escalation phase in
                  this field should be configured as such, from LSB to MSB:
                  <classA,phase0>...<classA,phase3>...<classD,phase0>...
                  <classD,phase3>. See the alert_handler documentation for
                  more details.
                  '''
                isdigest: false
                iszer: false
                ismubi: false
                iskeymgr_creator: false
                iskeymgr_owner: false
                absorb: false
                inv_default: 0
                offset: 1156
              }
              {
                name: OWNER_SW_CFG_ROM_ALERT_DIGEST_PROD
                size: 4
                desc:
                  '''
                  The expected CRC32 digest over all of the alert_handler
                  configurations set up by the ROM for a device operating in
                  the PROD LC state. The ROM reads this field and checks it
                  against a digest it computes over the alert_handler
                  configuration it programmed. This field is expected to be
                  automatically computed by the `otp_alert_digest()` Bazel
                  rule. See the `alert_config_crc32()` function in the
                  SiliconCreator alert_handler driver for more details on what
                  configurations are included in this digest.
                  '''
                isdigest: false
                iszer: false
                ismubi: false
                iskeymgr_creator: false
                iskeymgr_owner: false
                absorb: false
                inv_default: 0
                offset: 1220
              }
              {
                name: OWNER_SW_CFG_ROM_ALERT_DIGEST_PROD_END
                size: 4
                desc:
                  '''
                  Same as the `OWNER_SW_CFG_ROM_ALERT_DIGEST_PROD` field,
                  except the expected digest is for chips operating in the
                  PROD_END LC state.
                  '''
                isdigest: false
                iszer: false
                ismubi: false
                iskeymgr_creator: false
                iskeymgr_owner: false
                absorb: false
                inv_default: 0
                offset: 1224
              }
              {
                name: OWNER_SW_CFG_ROM_ALERT_DIGEST_DEV
                size: 4
                desc:
                  '''
                  Same as the `OWNER_SW_CFG_ROM_ALERT_DIGEST_PROD` field,
                  except the expected digest is for chips operating in the
                  DEV LC state.
                  '''
                isdigest: false
                iszer: false
                ismubi: false
                iskeymgr_creator: false
                iskeymgr_owner: false
                absorb: false
                inv_default: 0
                offset: 1228
              }
              {
                name: OWNER_SW_CFG_ROM_ALERT_DIGEST_RMA
                size: 4
                desc:
                  '''
                  Same as the `OWNER_SW_CFG_ROM_ALERT_DIGEST_PROD` field,
                  except the expected digest is for chips operating in the
                  RMA LC state.
                  '''
                isdigest: false
                iszer: false
                ismubi: false
                iskeymgr_creator: false
                iskeymgr_owner: false
                absorb: false
                inv_default: 0
                offset: 1232
              }
              {
                name: OWNER_SW_CFG_ROM_WATCHDOG_BITE_THRESHOLD_CYCLES
                size: 4
                desc: Watchdog timer bite threshold (in cycles) configured by the ROM.
                isdigest: false
                iszer: false
                ismubi: false
                iskeymgr_creator: false
                iskeymgr_owner: false
                absorb: false
                inv_default: 0
                offset: 1236
              }
              {
                name: OWNER_SW_CFG_ROM_KEYMGR_OTP_MEAS_EN
                size: 4
                desc:
                  '''
                  Whether or not to configure the attestation SW binding CSRs
                  of the keymgr with the value of the measurement of the OTP
                  CreatorSwCfg, OwnerSwCfg, and secure boot key integrity digest.
                  A value of kHardenedBoolTrue uses the ROM computed OTP
                  measurements.
                  '''
                isdigest: false
                iszer: false
                ismubi: false
                iskeymgr_creator: false
                iskeymgr_owner: false
                absorb: false
                inv_default: 0
                offset: 1240
              }
              {
                name: OWNER_SW_CFG_ROM_RSTMGR_INFO_EN
                size: 4
                desc:
                  '''
                  A two byte packed word that indicates the expected rstmgr
                  alert and CPU info dump enable states, configured in the
                  rstmgr's ALERT_INFO_CTRL and CPU_INFO_CTRL CSRs respectively.
                  The expected format of this fields is
                  {0,0,kHardenedBool*,kHardenedBool*}, read MSB to LSB, where
                  the left most kHardenedBool* entry indicates the expected
                  enablement state of the ALERT_INFO_CTRL, and the right most
                  indicates the enablement state of the CPU_INFO_CTRL. Since
                  the ROM expects both to be disabled upon handing over
                  execution control to the ROM_EXT, this entire OTP field
                  **should be left unprovisioned, or set to all 0**.
                  '''
                isdigest: false
                iszer: false
                ismubi: false
                iskeymgr_creator: false
                iskeymgr_owner: false
                absorb: false
                inv_default: 0
                offset: 1244
              }
              {
                name: OWNER_SW_CFG_DIGEST
                size: 8
                offset: 1248
                ismubi: false
                isdigest: true
                iszer: false
                inv_default: 3036799796741757437
                iskeymgr_creator: false
                iskeymgr_owner: false
              }
              {
                name: OWNER_SW_CFG_ZER
                size: 8
                offset: 1256
                ismubi: false
                isdigest: false
                iszer: true
                inv_default: 0
                iskeymgr_creator: false
                iskeymgr_owner: false
              }
            ]
            desc:
              '''
              Software configuration partition.
              This contains data that changes software behavior in the ROM, for
              example enabling defensive features in ROM or selecting failure
              modes if verification fails.
              '''
            iskeymgr_creator: false
            iskeymgr_owner: false
            ignore_read_lock_in_rma: false
            size: 968
            offset: 296
          }
          {
            name: OWNERSHIP_SLOT_STATE
            variant: Unbuffered
            absorb: false
            secret: false
            sw_digest: false
            hw_digest: false
            write_lock: None
            read_lock: CSR
            key_sel: NoKey
            integrity: true
            bkout_type: false
            zeroizable: true
            items:
            [
              {
                name: OWNERSHIP_SLOT_STATE_ROT_OWNER_AUTH
                size: 16
                desc:
                  '''
                  RoT Owner Ownership transfer state management
                  OWNERSHIP_ST_RAW:       ownership not yet claimed (factory default)
                  OWNERSHIP_ST_LOCKED0:   first ownership slot claimed
                  OWNERSHIP_ST_RELEASED0: first ownership slot released (assets have been cleared, ready to xfer)
                  OWNERSHIP_ST_LOCKED1:   second ownership slot claimed
                  OWNERSHIP_ST_SCRAPPED:  scrap state - terminal
                  '''
                isdigest: false
                iszer: false
                ismubi: false
                iskeymgr_creator: false
                iskeymgr_owner: false
                absorb: false
                inv_default: 0
                offset: 1264
              }
              {
                name: OWNERSHIP_SLOT_STATE_PLAT_INTEG_AUTH
                size: 16
                desc:
                  '''
                  Platform Integrator Ownership transfer state management
                  OWNERSHIP_ST_RAW:       ownership not yet claimed (factory default)
                  OWNERSHIP_ST_LOCKED0:   first ownership slot claimed
                  OWNERSHIP_ST_RELEASED0: first ownership slot released (assets have been cleared, ready to xfer)
                  OWNERSHIP_ST_LOCKED1:   second ownership slot claimed
                  OWNERSHIP_ST_SCRAPPED:  scrap state - terminal
                  '''
                isdigest: false
                iszer: false
                ismubi: false
                iskeymgr_creator: false
                iskeymgr_owner: false
                absorb: false
                inv_default: 0
                offset: 1280
              }
              {
                name: OWNERSHIP_SLOT_STATE_PLAT_OWNER_AUTH
                size: 16
                desc:
                  '''
                  Platform Owner Ownership transfer state management
                  OWNERSHIP_ST_RAW:       ownership not yet claimed (factory default)
                  OWNERSHIP_ST_LOCKED0:   first ownership slot claimed
                  OWNERSHIP_ST_RELEASED0: first ownership slot released (assets have been cleared, ready to xfer)
                  OWNERSHIP_ST_LOCKED1:   second ownership slot claimed
                  OWNERSHIP_ST_RELEASED1: second ownership slot released (assets have been cleared, ready to xfer)
                  OWNERSHIP_ST_LOCKED2:   third ownership slot claimed
                  OWNERSHIP_ST_RELEASED2: third ownership slot released (assets have been cleared, ready to xfer)
                  OWNERSHIP_ST_LOCKED3:   fourth ownership slot claimed
                  OWNERSHIP_ST_SCRAPPED:  scrap state - terminal
                  '''
                isdigest: false
                iszer: false
                ismubi: false
                iskeymgr_creator: false
                iskeymgr_owner: false
                absorb: false
                inv_default: 0
                offset: 1296
              }
              {
                name: OWNERSHIP_SLOT_STATE_ZER
                size: 8
                offset: 1312
                ismubi: false
                isdigest: false
                iszer: true
                inv_default: 0
                iskeymgr_creator: false
                iskeymgr_owner: false
              }
            ]
            desc:
              '''
              SW managed asset ownership states partition.

              Multi-bit enable value for the tracking the asset ownership states.
              Note that the states can be written multiple times in a device lifetime.
              The values to be written are engineered in the same way as the LC_CTRL
              state encoding words so that the ECC encoding remains valid even after
              updating the values.

              The constants can be found in the lc_ctrl_state_pkg.sv package.

              The programming order has to adhere to:

              OWNERSHIP_ST_RAW (factory all-zero state) ->
              OWNERSHIP_ST_LOCKED0 ->
              OWNERSHIP_ST_RELEASED0 ->
              ...
              OWNERSHIP_ST_SCRAPPED

              Note that if there are less than 4 slots available the higher slot states
              become logically equivalent to OWNERSHIP_SCRAPPED (firmware has to handle
              this correctly).
              '''
            iskeymgr_creator: false
            iskeymgr_owner: false
            ignore_read_lock_in_rma: false
            size: 56
            offset: 1264
          }
          {
            name: ROT_CREATOR_IDENTITY
            variant: Unbuffered
            absorb: false
            secret: false
            sw_digest: true
            hw_digest: false
            write_lock: Digest
            read_lock: CSR
            key_sel: NoKey
            integrity: true
            bkout_type: false
            zeroizable: true
            items:
            [
              {
                name: ROT_CREATOR_IDENTITY_CERT
                size: 768
                desc:
                  '''
                  RoT Device Identity Certificate endorsed by the Silicon Creator stable PKI (off device).
                  It is expected to be provisioned at Factory Testing (FT) stage when LC = DEV or PROD.
                  Provisioning happens through a secured channel between the DUT and the HSM, i.e. the key
                  is protected against supply-chain and manufacturing attacks.
                  '''
                isdigest: false
                iszer: false
                ismubi: false
                iskeymgr_creator: false
                iskeymgr_owner: false
                absorb: false
                inv_default: 0
                offset: 1320
              }
              {
                name: ROT_CREATOR_IDENTITY_CERT_CMAC
                size: 16
                desc: A Cipher-based MAC for the RoT Device Identity Certificate.
                isdigest: false
                iszer: false
                ismubi: false
                iskeymgr_creator: false
                iskeymgr_owner: false
                absorb: false
                inv_default: 0
                offset: 2088
              }
              {
                name: ROT_CREATOR_IDENTITY_DIGEST
                size: 8
                offset: 2104
                ismubi: false
                isdigest: true
                iszer: false
                inv_default: 13936327800626111575
                iskeymgr_creator: false
                iskeymgr_owner: false
              }
              {
                name: ROT_CREATOR_IDENTITY_ZER
                size: 8
                offset: 2112
                ismubi: false
                isdigest: false
                iszer: true
                inv_default: 0
                iskeymgr_creator: false
                iskeymgr_owner: false
              }
            ]
            desc: Software managed partition for the RoT Creator identity.
            iskeymgr_creator: false
            iskeymgr_owner: false
            ignore_read_lock_in_rma: false
            size: 800
            offset: 1320
          }
          {
            name: ROT_OWNER_AUTH_SLOT0
            variant: Unbuffered
            absorb: false
            secret: false
            sw_digest: true
            hw_digest: false
            write_lock: Digest
            read_lock: CSR
            key_sel: NoKey
            integrity: true
            bkout_type: false
            zeroizable: true
            items:
            [
              {
                name: ROT_OWNER_AUTH_SLOT0_NON_RAW_MFW_CODESIGN_KEY_TYPE
                size: 4
                desc:
                  '''
                  Key usage type. One of the following 32-bit values defined
                  by the sigverify API:
                  - kSigverifyKeyTypeTest for manufacturing, testing and RMA keys.
                  Keys of this type can be used only in TEST_UNLOCKED* and RMA life
                  cycle states.
                  - kSigverifyKeyTypeProd for production keys.
                  Keys of this type can be used in all operational life cycle states, i.e.
                  states in which CPU execution is enabled.
                  - kSigverifyKeyTypeDev for development keys.
                  Keys of this type can be used only in the DEV life cycle state.
                  '''
                isdigest: false
                iszer: false
                ismubi: false
                iskeymgr_creator: false
                iskeymgr_owner: false
                absorb: false
                inv_default: 0
                offset: 2120
              }
              {
                name: ROT_OWNER_AUTH_SLOT0_NON_RAW_MFW_CODESIGN_KEY_ROLE
                size: 4
                desc:
                  '''
                  Key role that describes the kind of assets a key could sign.
                  This must be set to the `kSigverifyKeyRoleBootstrapFirmwareSigning` 32-bit
                  value as defined by the sigverify API.
                  '''
                isdigest: false
                iszer: false
                ismubi: false
                iskeymgr_creator: false
                iskeymgr_owner: false
                absorb: false
                inv_default: 0
                offset: 2124
              }
              {
                name: ROT_OWNER_AUTH_SLOT0_NON_RAW_MFW_CODESIGN_KEY
                size: 64
                desc:
                  '''
                  Public Key used to verify manufacturing and debug firmware images.
                  Key Type: ECC NIST-P256 Curve.
                  It is expected to be provisioned at Final Test (FT) stage when LC = TEST_UNLOCKED.
                  Together with the ROM2_PATCH_SIGVERIFY_KEY and KEYMANIFEST_KEY keys, and their
                  associated device ID and metadata (stored in resp. KEY_DEVICE_ID and KEY_METADATA),
                  this key is signed with a Silicon Creator endorsed ECDSA P-256 key in order to protect
                  it from supply-chain and manufacturing attacks.
                  '''
                isdigest: false
                iszer: false
                ismubi: false
                iskeymgr_creator: false
                iskeymgr_owner: false
                absorb: false
                inv_default: 0
                offset: 2128
              }
              {
                name: ROT_OWNER_AUTH_SLOT0_ROM2_PATCH_SIGVERIFY_KEY_TYPE
                size: 4
                desc:
                  '''
                  Key usage type. One of the following 32-bit values defined
                  by the sigverify API:
                  - kSigverifyKeyTypeTest for manufacturing, testing and RMA keys.
                  Keys of this type can be used only in TEST_UNLOCKED* and RMA life
                  cycle states.
                  - kSigverifyKeyTypeProd for production keys.
                  Keys of this type can be used in all operational life cycle states, i.e.
                  states in which CPU execution is enabled.
                  - kSigverifyKeyTypeDev for development keys.
                  Keys of this type can be used only in the DEV life cycle state.
                  '''
                isdigest: false
                iszer: false
                ismubi: false
                iskeymgr_creator: false
                iskeymgr_owner: false
                absorb: false
                inv_default: 0
                offset: 2192
              }
              {
                name: ROT_OWNER_AUTH_SLOT0_ROM2_PATCH_SIGVERIFY_KEY_ROLE
                size: 4
                desc:
                  '''
                  Key role that describes the kind of assets a key could sign.
                  This must be set to the `kSigverifyKeyRoleRomPatchSigning` 32-bit
                  value as defined by the sigverify API.
                  '''
                isdigest: false
                iszer: false
                ismubi: false
                iskeymgr_creator: false
                iskeymgr_owner: false
                absorb: false
                inv_default: 0
                offset: 2196
              }
              {
                name: ROT_OWNER_AUTH_SLOT0_ROM2_PATCH_SIGVERIFY_KEY
                size: 64
                desc:
                  '''
                  Public Key used to verify the ROM2 OTP based patch.
                  Key Type: ECC NIST-P256 Curve.
                  It is expected to be provisioned at Final Test (FT) stage when LC = TEST_UNLOCKED.
                  Together with the NON_RAW_MFW_CODESIGN_KEY and KEYMANIFEST_KEY keys, and their
                  associated device ID and metadata (stored in resp. KEY_DEVICE_ID and KEY_METADATA),
                  this key is signed with a Silicon Creator endorsed ECDSA P-256 key in order to protect
                  it from supply-chain and manufacturing attacks.
                  '''
                isdigest: false
                iszer: false
                ismubi: false
                iskeymgr_creator: false
                iskeymgr_owner: false
                absorb: false
                inv_default: 0
                offset: 2200
              }
              {
                name: ROT_OWNER_AUTH_SLOT0_KEYMANIFEST_KEY_TYPE
                size: 4
                desc:
                  '''
                  Key usage type. One of the following 32-bit values defined
                  by the sigverify API:
                  - kSigverifyKeyTypeTest for manufacturing, testing and RMA keys.
                  Keys of this type can be used only in TEST_UNLOCKED* and RMA life
                  cycle states.
                  - kSigverifyKeyTypeProd for production keys.
                  Keys of this type can be used in all operational life cycle states, i.e.
                  states in which CPU execution is enabled.
                  - kSigverifyKeyTypeDev for development keys.
                  Keys of this type can be used only in the DEV life cycle state.
                  '''
                isdigest: false
                iszer: false
                ismubi: false
                iskeymgr_creator: false
                iskeymgr_owner: false
                absorb: false
                inv_default: 0
                offset: 2264
              }
              {
                name: ROT_OWNER_AUTH_SLOT0_KEYMANIFEST_KEY_ROLE
                size: 4
                desc:
                  '''
                  Key role that describes the kind of assets a key could sign.
                  This must be set to the `kSigverifyKeyRoleKeyBundleSigning` 32-bit
                  value as defined by the sigverify API.
                  '''
                isdigest: false
                iszer: false
                ismubi: false
                iskeymgr_creator: false
                iskeymgr_owner: false
                absorb: false
                inv_default: 0
                offset: 2268
              }
              {
                name: ROT_OWNER_AUTH_SLOT0_KEYMANIFEST_KEY
                size: 64
                desc:
                  '''
                  Public Key used to verify the RoT Creator (a.k.a. Silicon Creator) Key Manifest.
                  Key Type: ECC NIST-P256 Curve.
                  Together with the ROM2_PATCH_SIGVERIFY_KEY and NON_RAW_MFW_CODESIGN_KEY keys, and their
                  associated device ID and metadata (stored in resp. KEY_DEVICE_ID and KEY_METADATA),
                  this key is signed with a Silicon Creator endorsed ECDSA P-256 key in order to protect
                  it from supply-chain and manufacturing attacks.
                  '''
                isdigest: false
                iszer: false
                ismubi: false
                iskeymgr_creator: false
                iskeymgr_owner: false
                absorb: false
                inv_default: 0
                offset: 2272
              }
              {
                name: ROT_OWNER_AUTH_SLOT0_KEY_BINDING
                size: 64
                desc:
                  '''
                  A key binding value used to bind the ROT_OWNER_AUTH_SLOT0 keys to a SKU.
                  This item must store a SKU specific payload known at FT, like for example a fused
                  product identitfier or a ROM constant. The base ROM must verify the authenticity of
                  the ROT_OWNER_AUTH_SLOT0 first and then match the KEY_BINDING via an inline ROM check
                  before it uses the keys provisioned in this partition.
                  '''
                isdigest: false
                iszer: false
                ismubi: false
                iskeymgr_creator: false
                iskeymgr_owner: false
                absorb: false
                inv_default: 0
                offset: 2336
              }
              {
                name: ROT_OWNER_AUTH_SLOT0_KEY_SIGNATURE
                size: 64
                desc:
                  '''
                  ECDSA P-256 signature of the NON_RAW_MFW_CODESIGN_KEY,
                  ROM2_PATCH_SIGVERIFY_KEY, KEYMANIFEST_KEY, KEY_BINDING items in this partition.
                  As those three keys are expected to be provisioned at Final Test (FT) stage when
                  LC = TEST_UNLOCKED, this signatures aims at protecting them from supply-chain and
                  manufacturing attacks.
                  ROM images must include the corresponding signing key in order to verify all three
                  signatures.
                  '''
                isdigest: false
                iszer: false
                ismubi: false
                iskeymgr_creator: false
                iskeymgr_owner: false
                absorb: false
                inv_default: 0
                offset: 2400
              }
              {
                name: ROT_OWNER_AUTH_SLOT0_DIGEST
                size: 8
                offset: 2464
                ismubi: false
                isdigest: true
                iszer: false
                inv_default: 18001735645508761512
                iskeymgr_creator: false
                iskeymgr_owner: false
              }
              {
                name: ROT_OWNER_AUTH_SLOT0_ZER
                size: 8
                offset: 2472
                ismubi: false
                isdigest: false
                iszer: true
                inv_default: 0
                iskeymgr_creator: false
                iskeymgr_owner: false
              }
            ]
            desc: Software managed partition for the first RoT Owner (a.k.a. RoT Creator) key manifest.
            iskeymgr_creator: false
            iskeymgr_owner: false
            ignore_read_lock_in_rma: false
            size: 360
            offset: 2120
          }
          {
            name: ROT_OWNER_AUTH_SLOT1
            variant: Unbuffered
            absorb: false
            secret: false
            sw_digest: true
            hw_digest: false
            write_lock: Digest
            read_lock: CSR
            key_sel: NoKey
            integrity: true
            bkout_type: false
            zeroizable: true
            items:
            [
              {
                name: ROT_OWNER_AUTH_SLOT1_NON_RAW_MFW_CODESIGN_KEY_TYPE
                size: 4
                desc:
                  '''
                  Key usage type. One of the following 32-bit values defined
                  by the sigverify API:
                  - kSigverifyKeyTypeTest for manufacturing, testing and RMA keys.
                  Keys of this type can be used only in TEST_UNLOCKED* and RMA life
                  cycle states.
                  - kSigverifyKeyTypeProd for production keys.
                  Keys of this type can be used in all operational life cycle states, i.e.
                  states in which CPU execution is enabled.
                  - kSigverifyKeyTypeDev for development keys.
                  Keys of this type can be used only in the DEV life cycle state.
                  '''
                isdigest: false
                iszer: false
                ismubi: false
                iskeymgr_creator: false
                iskeymgr_owner: false
                absorb: false
                inv_default: 0
                offset: 2480
              }
              {
                name: ROT_OWNER_AUTH_SLOT1_NON_RAW_MFW_CODESIGN_KEY_ROLE
                size: 4
                desc:
                  '''
                  Key role that describes the kind of assets a key could sign.
                  This must be set to the `kSigverifyKeyRoleBootstrapFirmwareSigning` 32-bit
                  value as defined by the sigverify API.
                  '''
                isdigest: false
                iszer: false
                ismubi: false
                iskeymgr_creator: false
                iskeymgr_owner: false
                absorb: false
                inv_default: 0
                offset: 2484
              }
              {
                name: ROT_OWNER_AUTH_SLOT1_NON_RAW_MFW_CODESIGN_KEY
                size: 64
                desc:
                  '''
                  Public Key used to verify manufacturing and debug firmware images.
                  Key Type: ECC NIST-P256 Curve.
                  It is expected to be provisioned at Final Test (FT) stage when LC = TEST_UNLOCKED.
                  Together with the ROM2_PATCH_SIGVERIFY_KEY and KEYMANIFEST_KEY keys, and their
                  associated device ID and metadata (stored in resp. KEY_DEVICE_ID and KEY_METADATA),
                  this key is signed with a Silicon Creator endorsed ECDSA P-256 key in order to protect
                  it from supply-chain and manufacturing attacks.
                  '''
                isdigest: false
                iszer: false
                ismubi: false
                iskeymgr_creator: false
                iskeymgr_owner: false
                absorb: false
                inv_default: 0
                offset: 2488
              }
              {
                name: ROT_OWNER_AUTH_SLOT1_ROM2_PATCH_SIGVERIFY_KEY_TYPE
                size: 4
                desc:
                  '''
                  Key usage type. One of the following 32-bit values defined
                  by the sigverify API:
                  - kSigverifyKeyTypeTest for manufacturing, testing and RMA keys.
                  Keys of this type can be used only in TEST_UNLOCKED* and RMA life
                  cycle states.
                  - kSigverifyKeyTypeProd for production keys.
                  Keys of this type can be used in all operational life cycle states, i.e.
                  states in which CPU execution is enabled.
                  - kSigverifyKeyTypeDev for development keys.
                  Keys of this type can be used only in the DEV life cycle state.
                  '''
                isdigest: false
                iszer: false
                ismubi: false
                iskeymgr_creator: false
                iskeymgr_owner: false
                absorb: false
                inv_default: 0
                offset: 2552
              }
              {
                name: ROT_OWNER_AUTH_SLOT1_ROM2_PATCH_SIGVERIFY_KEY_ROLE
                size: 4
                desc:
                  '''
                  Key role that describes the kind of assets a key could sign.
                  This must be set to the `kSigverifyKeyRoleRomPatchSigning` 32-bit
                  value as defined by the sigverify API.
                  '''
                isdigest: false
                iszer: false
                ismubi: false
                iskeymgr_creator: false
                iskeymgr_owner: false
                absorb: false
                inv_default: 0
                offset: 2556
              }
              {
                name: ROT_OWNER_AUTH_SLOT1_ROM2_PATCH_SIGVERIFY_KEY
                size: 64
                desc:
                  '''
                  Public Key used to verify the ROM2 OTP based patch.
                  Key Type: ECC NIST-P256 Curve.
                  It is expected to be provisioned at Final Test (FT) stage when LC = TEST_UNLOCKED.
                  Together with the NON_RAW_MFW_CODESIGN_KEY and KEYMANIFEST_KEY keys, and their
                  associated device ID and metadata (stored in resp. KEY_DEVICE_ID and KEY_METADATA),
                  this key is signed with a Silicon Creator endorsed ECDSA P-256 key in order to protect
                  it from supply-chain and manufacturing attacks.
                  '''
                isdigest: false
                iszer: false
                ismubi: false
                iskeymgr_creator: false
                iskeymgr_owner: false
                absorb: false
                inv_default: 0
                offset: 2560
              }
              {
                name: ROT_OWNER_AUTH_SLOT1_KEYMANIFEST_KEY_TYPE
                size: 4
                desc:
                  '''
                  Key usage type. One of the following 32-bit values defined
                  by the sigverify API:
                  - kSigverifyKeyTypeTest for manufacturing, testing and RMA keys.
                  Keys of this type can be used only in TEST_UNLOCKED* and RMA life
                  cycle states.
                  - kSigverifyKeyTypeProd for production keys.
                  Keys of this type can be used in all operational life cycle states, i.e.
                  states in which CPU execution is enabled.
                  - kSigverifyKeyTypeDev for development keys.
                  Keys of this type can be used only in the DEV life cycle state.
                  '''
                isdigest: false
                iszer: false
                ismubi: false
                iskeymgr_creator: false
                iskeymgr_owner: false
                absorb: false
                inv_default: 0
                offset: 2624
              }
              {
                name: ROT_OWNER_AUTH_SLOT1_KEYMANIFEST_KEY_ROLE
                size: 4
                desc:
                  '''
                  Key role that describes the kind of assets a key could sign.
                  This must be set to the `kSigverifyKeyRoleKeyBundleSigning` 32-bit
                  value as defined by the sigverify API.
                  '''
                isdigest: false
                iszer: false
                ismubi: false
                iskeymgr_creator: false
                iskeymgr_owner: false
                absorb: false
                inv_default: 0
                offset: 2628
              }
              {
                name: ROT_OWNER_AUTH_SLOT1_KEYMANIFEST_KEY
                size: 64
                desc:
                  '''
                  Public Key used to verify the RoT Owner (a.k.a. Silicon Owner) Key Manifest.
                  Key Type: ECC NIST-P256 Curve.
                  It is expected to be provisioned as part of the RoT Owner intra-role ownership transfer
                  process, when LC = PROD.
                  Provisioning happens through an Ownership Claim operation, after the previous RoT
                  Owner completed a Relinquish operation.
                  '''
                isdigest: false
                iszer: false
                ismubi: false
                iskeymgr_creator: false
                iskeymgr_owner: false
                absorb: false
                inv_default: 0
                offset: 2632
              }
              {
                name: ROT_OWNER_AUTH_SLOT1_UNLOCK4XFER_KEY_TYPE
                size: 4
                desc:
                  '''
                  Key usage type. One of the following 32-bit values defined
                  by the sigverify API:
                  - kSigverifyKeyTypeTest for manufacturing, testing and RMA keys.
                  Keys of this type can be used only in TEST_UNLOCKED* and RMA life
                  cycle states.
                  - kSigverifyKeyTypeProd for production keys.
                  Keys of this type can be used in all operational life cycle states, i.e.
                  states in which CPU execution is enabled.
                  - kSigverifyKeyTypeDev for development keys.
                  Keys of this type can be used only in the DEV life cycle state.
                  '''
                isdigest: false
                iszer: false
                ismubi: false
                iskeymgr_creator: false
                iskeymgr_owner: false
                absorb: false
                inv_default: 0
                offset: 2696
              }
              {
                name: ROT_OWNER_AUTH_SLOT1_UNLOCK4XFER_KEY_ROLE
                size: 4
                desc:
                  '''
                  Key role that describes the kind of assets a key could sign.
                  This must be set to the `kSigverifyKeyRoleRelinquishOwnership` 32-bit
                  value as defined by the sigverify API.
                  '''
                isdigest: false
                iszer: false
                ismubi: false
                iskeymgr_creator: false
                iskeymgr_owner: false
                absorb: false
                inv_default: 0
                offset: 2700
              }
              {
                name: ROT_OWNER_AUTH_SLOT1_UNLOCK4XFER_KEY
                size: 64
                desc:
                  '''
                  Public Key used to verify the RoT Owner Unlock Ownership firmware image.
                  Key Type: ECC NIST-P256 Curve.
                  It is expected to be provisioned as part of the RoT Owner intra-role ownership transfer
                  process, when LC = PROD.
                  Provisioning happens through an Ownership Claim operation, after the previous RoT
                  Owner completed a Relinquish operation.
                  '''
                isdigest: false
                iszer: false
                ismubi: false
                iskeymgr_creator: false
                iskeymgr_owner: false
                absorb: false
                inv_default: 0
                offset: 2704
              }
              {
                name: ROT_OWNER_AUTH_SLOT1_DIGEST
                size: 8
                offset: 2768
                ismubi: false
                isdigest: true
                iszer: false
                inv_default: 5471265045120329804
                iskeymgr_creator: false
                iskeymgr_owner: false
              }
              {
                name: ROT_OWNER_AUTH_SLOT1_ZER
                size: 8
                offset: 2776
                ismubi: false
                isdigest: false
                iszer: true
                inv_default: 0
                iskeymgr_creator: false
                iskeymgr_owner: false
              }
            ]
            desc: Software managed RoT Owner slot 1 partition.
            iskeymgr_creator: false
            iskeymgr_owner: false
            ignore_read_lock_in_rma: false
            size: 304
            offset: 2480
          }
          {
            name: PLAT_INTEG_AUTH_SLOT0
            variant: Unbuffered
            absorb: false
            secret: false
            sw_digest: true
            hw_digest: false
            write_lock: Digest
            read_lock: CSR
            key_sel: NoKey
            integrity: true
            bkout_type: false
            zeroizable: true
            items:
            [
              {
                name: PLAT_INTEG_AUTH_SLOT0_KEYMANIFEST_KEY_TYPE
                size: 4
                desc:
                  '''
                  Key usage type. One of the following 32-bit values defined
                  by the sigverify API:
                  - kSigverifyKeyTypeTest for manufacturing, testing and RMA keys.
                  Keys of this type can be used only in TEST_UNLOCKED* and RMA life
                  cycle states.
                  - kSigverifyKeyTypeProd for production keys.
                  Keys of this type can be used in all operational life cycle states, i.e.
                  states in which CPU execution is enabled.
                  - kSigverifyKeyTypeDev for development keys.
                  Keys of this type can be used only in the DEV life cycle state.
                  '''
                isdigest: false
                iszer: false
                ismubi: false
                iskeymgr_creator: false
                iskeymgr_owner: false
                absorb: false
                inv_default: 0
                offset: 2784
              }
              {
                name: PLAT_INTEG_AUTH_SLOT0_KEYMANIFEST_KEY_ROLE
                size: 4
                desc:
                  '''
                  Key role that describes the kind of assets a key could sign.
                  This must be set to the `kSigverifyKeyRoleKeyBundleSigning` 32-bit
                  value as defined by the sigverify API.
                  '''
                isdigest: false
                iszer: false
                ismubi: false
                iskeymgr_creator: false
                iskeymgr_owner: false
                absorb: false
                inv_default: 0
                offset: 2788
              }
              {
                name: PLAT_INTEG_AUTH_SLOT0_KEYMANIFEST_KEY
                size: 64
                desc:
                  '''
                  Public Key used to verify the Platform Integrator Key Manifest.
                  Key Type: ECC NIST-P256 Curve.
                  This should be provisioned during the Platform Integrator Activation process, at the Platform
                  Integrator's manufacturing facilities.
                  The initial Platform Integrator provisions its Key Manifest public key using the provisioning
                  boot service provided by the current RoT Owner.
                  '''
                isdigest: false
                iszer: false
                ismubi: false
                iskeymgr_creator: false
                iskeymgr_owner: false
                absorb: false
                inv_default: 0
                offset: 2792
              }
              {
                name: PLAT_INTEG_AUTH_SLOT0_UNLOCK4XFER_KEY_TYPE
                size: 4
                desc:
                  '''
                  Key usage type. One of the following 32-bit values defined
                  by the sigverify API:
                  - kSigverifyKeyTypeTest for manufacturing, testing and RMA keys.
                  Keys of this type can be used only in TEST_UNLOCKED* and RMA life
                  cycle states.
                  - kSigverifyKeyTypeProd for production keys.
                  Keys of this type can be used in all operational life cycle states, i.e.
                  states in which CPU execution is enabled.
                  - kSigverifyKeyTypeDev for development keys.
                  Keys of this type can be used only in the DEV life cycle state.
                  '''
                isdigest: false
                iszer: false
                ismubi: false
                iskeymgr_creator: false
                iskeymgr_owner: false
                absorb: false
                inv_default: 0
                offset: 2856
              }
              {
                name: PLAT_INTEG_AUTH_SLOT0_UNLOCK4XFER_KEY_ROLE
                size: 4
                desc:
                  '''
                  Key role that describes the kind of assets a key could sign.
                  This must be set to the `kSigverifyKeyRoleRelinquishOwnership` 32-bit
                  value as defined by the sigverify API.
                  '''
                isdigest: false
                iszer: false
                ismubi: false
                iskeymgr_creator: false
                iskeymgr_owner: false
                absorb: false
                inv_default: 0
                offset: 2860
              }
              {
                name: PLAT_INTEG_AUTH_SLOT0_UNLOCK4XFER_KEY
                size: 64
                desc:
                  '''
                  Public Key used to verify the Platform Integrator Unlock Ownership firmware image.
                  Key Type: ECC NIST-P256 Curve.
                  This should be provisioned during the Platform Integrator Activation process, at the Platform
                  Integrator's manufacturing facilities.
                  The initial Platform Integrator provisions its Key Manifest public key using the provisioning
                  boot service provided by the current RoT Owner.
                  '''
                isdigest: false
                iszer: false
                ismubi: false
                iskeymgr_creator: false
                iskeymgr_owner: false
                absorb: false
                inv_default: 0
                offset: 2864
              }
              {
                name: PLAT_INTEG_AUTH_SLOT0_DIGEST
                size: 8
                offset: 2928
                ismubi: false
                isdigest: true
                iszer: false
                inv_default: 18297828617386945793
                iskeymgr_creator: false
                iskeymgr_owner: false
              }
              {
                name: PLAT_INTEG_AUTH_SLOT0_ZER
                size: 8
                offset: 2936
                ismubi: false
                isdigest: false
                iszer: true
                inv_default: 0
                iskeymgr_creator: false
                iskeymgr_owner: false
              }
            ]
            desc: Software managed Platform Integrator slot 0 partition.
            iskeymgr_creator: false
            iskeymgr_owner: false
            ignore_read_lock_in_rma: false
            size: 160
            offset: 2784
          }
          {
            name: PLAT_INTEG_AUTH_SLOT1
            variant: Unbuffered
            absorb: false
            secret: false
            sw_digest: true
            hw_digest: false
            write_lock: Digest
            read_lock: CSR
            key_sel: NoKey
            integrity: true
            bkout_type: false
            zeroizable: true
            items:
            [
              {
                name: PLAT_INTEG_AUTH_SLOT1_KEYMANIFEST_KEY_TYPE
                size: 4
                desc:
                  '''
                  Key usage type. One of the following 32-bit values defined
                  by the sigverify API:
                  - kSigverifyKeyTypeTest for manufacturing, testing and RMA keys.
                  Keys of this type can be used only in TEST_UNLOCKED* and RMA life
                  cycle states.
                  - kSigverifyKeyTypeProd for production keys.
                  Keys of this type can be used in all operational life cycle states, i.e.
                  states in which CPU execution is enabled.
                  - kSigverifyKeyTypeDev for development keys.
                  Keys of this type can be used only in the DEV life cycle state.
                  '''
                isdigest: false
                iszer: false
                ismubi: false
                iskeymgr_creator: false
                iskeymgr_owner: false
                absorb: false
                inv_default: 0
                offset: 2944
              }
              {
                name: PLAT_INTEG_AUTH_SLOT1_KEYMANIFEST_KEY_ROLE
                size: 4
                desc:
                  '''
                  Key role that describes the kind of assets a key could sign.
                  This must be set to the `kSigverifyKeyRoleKeyBundleSigning` 32-bit
                  value as defined by the sigverify API.
                  '''
                isdigest: false
                iszer: false
                ismubi: false
                iskeymgr_creator: false
                iskeymgr_owner: false
                absorb: false
                inv_default: 0
                offset: 2948
              }
              {
                name: PLAT_INTEG_AUTH_SLOT1_KEYMANIFEST_KEY
                size: 64
                desc:
                  '''
                  Public Key used to verify the Platform Integrator Key Manifest.
                  Key Type: ECC NIST-P256 Curve.
                  This should be provisioned during the Platform Integrator intra-role ownership transfer
                  process when the lifecycle state (LC) is PROD. Provisioning occurs via an Ownership Claim
                  operation after the previous Platform Integrator completes a Relinquish operation.
                  '''
                isdigest: false
                iszer: false
                ismubi: false
                iskeymgr_creator: false
                iskeymgr_owner: false
                absorb: false
                inv_default: 0
                offset: 2952
              }
              {
                name: PLAT_INTEG_AUTH_SLOT1_UNLOCK4XFER_KEY_TYPE
                size: 4
                desc:
                  '''
                  Key usage type. One of the following 32-bit values defined
                  by the sigverify API:
                  - kSigverifyKeyTypeTest for manufacturing, testing and RMA keys.
                  Keys of this type can be used only in TEST_UNLOCKED* and RMA life
                  cycle states.
                  - kSigverifyKeyTypeProd for production keys.
                  Keys of this type can be used in all operational life cycle states, i.e.
                  states in which CPU execution is enabled.
                  - kSigverifyKeyTypeDev for development keys.
                  Keys of this type can be used only in the DEV life cycle state.
                  '''
                isdigest: false
                iszer: false
                ismubi: false
                iskeymgr_creator: false
                iskeymgr_owner: false
                absorb: false
                inv_default: 0
                offset: 3016
              }
              {
                name: PLAT_INTEG_AUTH_SLOT1_UNLOCK4XFER_KEY_ROLE
                size: 4
                desc:
                  '''
                  Key role that describes the kind of assets a key could sign.
                  This must be set to the `kSigverifyKeyRoleRelinquishOwnership` 32-bit
                  value as defined by the sigverify API.
                  '''
                isdigest: false
                iszer: false
                ismubi: false
                iskeymgr_creator: false
                iskeymgr_owner: false
                absorb: false
                inv_default: 0
                offset: 3020
              }
              {
                name: PLAT_INTEG_AUTH_SLOT1_UNLOCK4XFER_KEY
                size: 64
                desc:
                  '''
                  Public Key used to verify the Platform Integrator Unlock Ownership firmware image
                  Key Type: ECC NIST-P256 Curve.
                  This should be provisioned during the Platform Integrator intra-role ownership transfer
                  process when the lifecycle state (LC) is PROD. Provisioning occurs via an Ownership Claim
                  operation after the previous Platform Integrator completes a Relinquish operation.
                  '''
                isdigest: false
                iszer: false
                ismubi: false
                iskeymgr_creator: false
                iskeymgr_owner: false
                absorb: false
                inv_default: 0
                offset: 3024
              }
              {
                name: PLAT_INTEG_AUTH_SLOT1_DIGEST
                size: 8
                offset: 3088
                ismubi: false
                isdigest: true
                iszer: false
                inv_default: 13047861355720130167
                iskeymgr_creator: false
                iskeymgr_owner: false
              }
              {
                name: PLAT_INTEG_AUTH_SLOT1_ZER
                size: 8
                offset: 3096
                ismubi: false
                isdigest: false
                iszer: true
                inv_default: 0
                iskeymgr_creator: false
                iskeymgr_owner: false
              }
            ]
            desc: Software managed Platform Integrator slot 1 partition.
            iskeymgr_creator: false
            iskeymgr_owner: false
            ignore_read_lock_in_rma: false
            size: 160
            offset: 2944
          }
          {
            name: PLAT_OWNER_AUTH_SLOT0
            variant: Unbuffered
            absorb: false
            secret: false
            sw_digest: true
            hw_digest: false
            write_lock: Digest
            read_lock: CSR
            key_sel: NoKey
            integrity: true
            bkout_type: false
            zeroizable: true
            items:
            [
              {
                name: PLAT_OWNER_AUTH_SLOT0_KEYMANIFEST_KEY_TYPE
                size: 4
                desc:
                  '''
                  Key usage type. One of the following 32-bit values defined
                  by the sigverify API:
                  - kSigverifyKeyTypeTest for manufacturing, testing and RMA keys.
                  Keys of this type can be used only in TEST_UNLOCKED* and RMA life
                  cycle states.
                  - kSigverifyKeyTypeProd for production keys.
                  Keys of this type can be used in all operational life cycle states, i.e.
                  states in which CPU execution is enabled.
                  - kSigverifyKeyTypeDev for development keys.
                  Keys of this type can be used only in the DEV life cycle state.
                  '''
                isdigest: false
                iszer: false
                ismubi: false
                iskeymgr_creator: false
                iskeymgr_owner: false
                absorb: false
                inv_default: 0
                offset: 3104
              }
              {
                name: PLAT_OWNER_AUTH_SLOT0_KEYMANIFEST_KEY_ROLE
                size: 4
                desc:
                  '''
                  Key role that describes the kind of assets a key could sign.
                  This must be set to the `kSigverifyKeyRoleKeyBundleSigning` 32-bit
                  value as defined by the sigverify API.
                  '''
                isdigest: false
                iszer: false
                ismubi: false
                iskeymgr_creator: false
                iskeymgr_owner: false
                absorb: false
                inv_default: 0
                offset: 3108
              }
              {
                name: PLAT_OWNER_AUTH_SLOT0_KEYMANIFEST_KEY
                size: 64
                desc:
                  '''
                  Public Key used to verify the Platform Owner Key Manifest.
                  Key Type: ECC NIST-P256 Curve.
                  This should be provisioned during the Platform Owner Activation process, at the Platform
                  Owner's facilities.
                  The initial Platform Owner provisions its Key Manifest public key using the provisioning
                  boot service provided by the current RoT Owner.
                  '''
                isdigest: false
                iszer: false
                ismubi: false
                iskeymgr_creator: false
                iskeymgr_owner: false
                absorb: false
                inv_default: 0
                offset: 3112
              }
              {
                name: PLAT_OWNER_AUTH_SLOT0_UNLOCK4XFER_KEY_TYPE
                size: 4
                desc:
                  '''
                  Key usage type. One of the following 32-bit values defined
                  by the sigverify API:
                  - kSigverifyKeyTypeTest for manufacturing, testing and RMA keys.
                  Keys of this type can be used only in TEST_UNLOCKED* and RMA life
                  cycle states.
                  - kSigverifyKeyTypeProd for production keys.
                  Keys of this type can be used in all operational life cycle states, i.e.
                  states in which CPU execution is enabled.
                  - kSigverifyKeyTypeDev for development keys.
                  Keys of this type can be used only in the DEV life cycle state.
                  '''
                isdigest: false
                iszer: false
                ismubi: false
                iskeymgr_creator: false
                iskeymgr_owner: false
                absorb: false
                inv_default: 0
                offset: 3176
              }
              {
                name: PLAT_OWNER_AUTH_SLOT0_UNLOCK4XFER_KEY_ROLE
                size: 4
                desc:
                  '''
                  Key role that describes the kind of assets a key could sign.
                  This must be set to the `kSigverifyKeyRoleRelinquishOwnership` 32-bit
                  value as defined by the sigverify API.
                  '''
                isdigest: false
                iszer: false
                ismubi: false
                iskeymgr_creator: false
                iskeymgr_owner: false
                absorb: false
                inv_default: 0
                offset: 3180
              }
              {
                name: PLAT_OWNER_AUTH_SLOT0_UNLOCK4XFER_KEY
                size: 64
                desc:
                  '''
                  Public Key used to verify the Platform Owner Unlock Ownership firmware image.
                  Key Type: ECC NIST-P256 Curve.
                  This should be provisioned during the Platform Owner Activation process, at the Platform
                  Owner's facilities.
                  The initial Platform Owner provisions its Key Manifest public key using the provisioning
                  boot service provided by the current RoT Owner.
                  '''
                isdigest: false
                iszer: false
                ismubi: false
                iskeymgr_creator: false
                iskeymgr_owner: false
                absorb: false
                inv_default: 0
                offset: 3184
              }
              {
                name: PLAT_OWNER_AUTH_SLOT0_DIGEST
                size: 8
                offset: 3248
                ismubi: false
                isdigest: true
                iszer: false
                inv_default: 13089428196878425884
                iskeymgr_creator: false
                iskeymgr_owner: false
              }
              {
                name: PLAT_OWNER_AUTH_SLOT0_ZER
                size: 8
                offset: 3256
                ismubi: false
                isdigest: false
                iszer: true
                inv_default: 0
                iskeymgr_creator: false
                iskeymgr_owner: false
              }
            ]
            desc: Software managed Platform Owner slot 0 partition.
            iskeymgr_creator: false
            iskeymgr_owner: false
            ignore_read_lock_in_rma: false
            size: 160
            offset: 3104
          }
          {
            name: PLAT_OWNER_AUTH_SLOT1
            variant: Unbuffered
            absorb: false
            secret: false
            sw_digest: true
            hw_digest: false
            write_lock: Digest
            read_lock: CSR
            key_sel: NoKey
            integrity: true
            bkout_type: false
            zeroizable: true
            items:
            [
              {
                name: PLAT_OWNER_AUTH_SLOT1_KEYMANIFEST_KEY_TYPE
                size: 4
                desc:
                  '''
                  Key usage type. One of the following 32-bit values defined
                  by the sigverify API:
                  - kSigverifyKeyTypeTest for manufacturing, testing and RMA keys.
                  Keys of this type can be used only in TEST_UNLOCKED* and RMA life
                  cycle states.
                  - kSigverifyKeyTypeProd for production keys.
                  Keys of this type can be used in all operational life cycle states, i.e.
                  states in which CPU execution is enabled.
                  - kSigverifyKeyTypeDev for development keys.
                  Keys of this type can be used only in the DEV life cycle state.
                  '''
                isdigest: false
                iszer: false
                ismubi: false
                iskeymgr_creator: false
                iskeymgr_owner: false
                absorb: false
                inv_default: 0
                offset: 3264
              }
              {
                name: PLAT_OWNER_AUTH_SLOT1_KEYMANIFEST_KEY_ROLE
                size: 4
                desc:
                  '''
                  Key role that describes the kind of assets a key could sign.
                  This must be set to the `kSigverifyKeyRoleKeyBundleSigning` 32-bit
                  value as defined by the sigverify API.
                  '''
                isdigest: false
                iszer: false
                ismubi: false
                iskeymgr_creator: false
                iskeymgr_owner: false
                absorb: false
                inv_default: 0
                offset: 3268
              }
              {
                name: PLAT_OWNER_AUTH_SLOT1_KEYMANIFEST_KEY
                size: 64
                desc:
                  '''
                  Public Key used to verify the Platform Owner Key Manifest.
                  Key Type: ECC NIST-P256 Curve.
                  This should be provisioned during the Platform Owner intra-role ownership transfer
                  process when the lifecycle state (LC) is PROD. Provisioning occurs via an Ownership Claim
                  operation after the previous Platform Owner completes a Relinquish operation.
                  '''
                isdigest: false
                iszer: false
                ismubi: false
                iskeymgr_creator: false
                iskeymgr_owner: false
                absorb: false
                inv_default: 0
                offset: 3272
              }
              {
                name: PLAT_OWNER_AUTH_SLOT1_UNLOCK4XFER_KEY_TYPE
                size: 4
                desc:
                  '''
                  Key usage type. One of the following 32-bit values defined
                  by the sigverify API:
                  - kSigverifyKeyTypeTest for manufacturing, testing and RMA keys.
                  Keys of this type can be used only in TEST_UNLOCKED* and RMA life
                  cycle states.
                  - kSigverifyKeyTypeProd for production keys.
                  Keys of this type can be used in all operational life cycle states, i.e.
                  states in which CPU execution is enabled.
                  - kSigverifyKeyTypeDev for development keys.
                  Keys of this type can be used only in the DEV life cycle state.
                  '''
                isdigest: false
                iszer: false
                ismubi: false
                iskeymgr_creator: false
                iskeymgr_owner: false
                absorb: false
                inv_default: 0
                offset: 3336
              }
              {
                name: PLAT_OWNER_AUTH_SLOT1_UNLOCK4XFER_KEY_ROLE
                size: 4
                desc:
                  '''
                  Key role that describes the kind of assets a key could sign.
                  This must be set to the `kSigverifyKeyRoleRelinquishOwnership` 32-bit
                  value as defined by the sigverify API.
                  '''
                isdigest: false
                iszer: false
                ismubi: false
                iskeymgr_creator: false
                iskeymgr_owner: false
                absorb: false
                inv_default: 0
                offset: 3340
              }
              {
                name: PLAT_OWNER_AUTH_SLOT1_UNLOCK4XFER_KEY
                size: 64
                desc:
                  '''
                  Public Key used to verify the Platform Owner Unlock Ownership firmware image.
                  Key Type: ECC NIST-P256 Curve.
                  This should be provisioned during the Platform Owner intra-role ownership transfer
                  process when the lifecycle state (LC) is PROD. Provisioning occurs via an Ownership Claim
                  operation after the previous Platform Owner completes a Relinquish operation.
                  '''
                isdigest: false
                iszer: false
                ismubi: false
                iskeymgr_creator: false
                iskeymgr_owner: false
                absorb: false
                inv_default: 0
                offset: 3344
              }
              {
                name: PLAT_OWNER_AUTH_SLOT1_DIGEST
                size: 8
                offset: 3408
                ismubi: false
                isdigest: true
                iszer: false
                inv_default: 9966431396093675977
                iskeymgr_creator: false
                iskeymgr_owner: false
              }
              {
                name: PLAT_OWNER_AUTH_SLOT1_ZER
                size: 8
                offset: 3416
                ismubi: false
                isdigest: false
                iszer: true
                inv_default: 0
                iskeymgr_creator: false
                iskeymgr_owner: false
              }
            ]
            desc: Software managed Platform Owner slot 1 partition.
            iskeymgr_creator: false
            iskeymgr_owner: false
            ignore_read_lock_in_rma: false
            size: 160
            offset: 3264
          }
          {
            name: PLAT_OWNER_AUTH_SLOT2
            variant: Unbuffered
            absorb: false
            secret: false
            sw_digest: true
            hw_digest: false
            write_lock: Digest
            read_lock: CSR
            key_sel: NoKey
            integrity: true
            bkout_type: false
            zeroizable: true
            items:
            [
              {
                name: PLAT_OWNER_AUTH_SLOT2_KEYMANIFEST_KEY_TYPE
                size: 4
                desc:
                  '''
                  Key usage type. One of the following 32-bit values defined
                  by the sigverify API:
                  - kSigverifyKeyTypeTest for manufacturing, testing and RMA keys.
                  Keys of this type can be used only in TEST_UNLOCKED* and RMA life
                  cycle states.
                  - kSigverifyKeyTypeProd for production keys.
                  Keys of this type can be used in all operational life cycle states, i.e.
                  states in which CPU execution is enabled.
                  - kSigverifyKeyTypeDev for development keys.
                  Keys of this type can be used only in the DEV life cycle state.
                  '''
                isdigest: false
                iszer: false
                ismubi: false
                iskeymgr_creator: false
                iskeymgr_owner: false
                absorb: false
                inv_default: 0
                offset: 3424
              }
              {
                name: PLAT_OWNER_AUTH_SLOT2_KEYMANIFEST_KEY_ROLE
                size: 4
                desc:
                  '''
                  Key role that describes the kind of assets a key could sign.
                  This must be set to the `kSigverifyKeyRoleKeyBundleSigning` 32-bit
                  value as defined by the sigverify API.
                  '''
                isdigest: false
                iszer: false
                ismubi: false
                iskeymgr_creator: false
                iskeymgr_owner: false
                absorb: false
                inv_default: 0
                offset: 3428
              }
              {
                name: PLAT_OWNER_AUTH_SLOT2_KEYMANIFEST_KEY
                size: 64
                desc:
                  '''
                  Public Key used to verify the Platform Owner Key Manifest.
                  Key Type: ECC NIST-P256 Curve.
                  This should be provisioned during the Platform Owner intra-role ownership transfer
                  process when the lifecycle state (LC) is PROD. Provisioning occurs via an Ownership Claim
                  operation after the previous Platform Owner completes a Relinquish operation.
                  '''
                isdigest: false
                iszer: false
                ismubi: false
                iskeymgr_creator: false
                iskeymgr_owner: false
                absorb: false
                inv_default: 0
                offset: 3432
              }
              {
                name: PLAT_OWNER_AUTH_SLOT2_UNLOCK4XFER_KEY_TYPE
                size: 4
                desc:
                  '''
                  Key usage type. One of the following 32-bit values defined
                  by the sigverify API:
                  - kSigverifyKeyTypeTest for manufacturing, testing and RMA keys.
                  Keys of this type can be used only in TEST_UNLOCKED* and RMA life
                  cycle states.
                  - kSigverifyKeyTypeProd for production keys.
                  Keys of this type can be used in all operational life cycle states, i.e.
                  states in which CPU execution is enabled.
                  - kSigverifyKeyTypeDev for development keys.
                  Keys of this type can be used only in the DEV life cycle state.
                  '''
                isdigest: false
                iszer: false
                ismubi: false
                iskeymgr_creator: false
                iskeymgr_owner: false
                absorb: false
                inv_default: 0
                offset: 3496
              }
              {
                name: PLAT_OWNER_AUTH_SLOT2_UNLOCK4XFER_KEY_ROLE
                size: 4
                desc:
                  '''
                  Key role that describes the kind of assets a key could sign.
                  This must be set to the `kSigverifyKeyRoleRelinquishOwnership` 32-bit
                  value as defined by the sigverify API.
                  '''
                isdigest: false
                iszer: false
                ismubi: false
                iskeymgr_creator: false
                iskeymgr_owner: false
                absorb: false
                inv_default: 0
                offset: 3500
              }
              {
                name: PLAT_OWNER_AUTH_SLOT2_UNLOCK4XFER_KEY
                size: 64
                desc:
                  '''
                  Public Key used to verify the Platform Owner Unlock Ownership firmware image.
                  Key Type: ECC NIST-P256 Curve.
                  This should be provisioned during the Platform Owner intra-role ownership transfer
                  process when the lifecycle state (LC) is PROD. Provisioning occurs via an Ownership Claim
                  operation after the previous Platform Owner completes a Relinquish operation.
                  '''
                isdigest: false
                iszer: false
                ismubi: false
                iskeymgr_creator: false
                iskeymgr_owner: false
                absorb: false
                inv_default: 0
                offset: 3504
              }
              {
                name: PLAT_OWNER_AUTH_SLOT2_DIGEST
                size: 8
                offset: 3568
                ismubi: false
                isdigest: true
                iszer: false
                inv_default: 16981414814768445627
                iskeymgr_creator: false
                iskeymgr_owner: false
              }
              {
                name: PLAT_OWNER_AUTH_SLOT2_ZER
                size: 8
                offset: 3576
                ismubi: false
                isdigest: false
                iszer: true
                inv_default: 0
                iskeymgr_creator: false
                iskeymgr_owner: false
              }
            ]
            desc: Software managed Platform Owner slot 2 partition.
            iskeymgr_creator: false
            iskeymgr_owner: false
            ignore_read_lock_in_rma: false
            size: 160
            offset: 3424
          }
          {
            name: PLAT_OWNER_AUTH_SLOT3
            variant: Unbuffered
            absorb: false
            secret: false
            sw_digest: true
            hw_digest: false
            write_lock: Digest
            read_lock: CSR
            key_sel: NoKey
            integrity: true
            bkout_type: false
            zeroizable: true
            items:
            [
              {
                name: PLAT_OWNER_AUTH_SLOT3_KEYMANIFEST_KEY_TYPE
                size: 4
                desc:
                  '''
                  Key usage type. One of the following 32-bit values defined
                  by the sigverify API:
                  - kSigverifyKeyTypeTest for manufacturing, testing and RMA keys.
                  Keys of this type can be used only in TEST_UNLOCKED* and RMA life
                  cycle states.
                  - kSigverifyKeyTypeProd for production keys.
                  Keys of this type can be used in all operational life cycle states, i.e.
                  states in which CPU execution is enabled.
                  - kSigverifyKeyTypeDev for development keys.
                  Keys of this type can be used only in the DEV life cycle state.
                  '''
                isdigest: false
                iszer: false
                ismubi: false
                iskeymgr_creator: false
                iskeymgr_owner: false
                absorb: false
                inv_default: 0
                offset: 3584
              }
              {
                name: PLAT_OWNER_AUTH_SLOT3_KEYMANIFEST_KEY_ROLE
                size: 4
                desc:
                  '''
                  Key role that describes the kind of assets a key could sign.
                  This must be set to the `kSigverifyKeyRoleKeyBundleSigning` 32-bit
                  value as defined by the sigverify API.
                  '''
                isdigest: false
                iszer: false
                ismubi: false
                iskeymgr_creator: false
                iskeymgr_owner: false
                absorb: false
                inv_default: 0
                offset: 3588
              }
              {
                name: PLAT_OWNER_AUTH_SLOT3_KEYMANIFEST_KEY
                size: 64
                desc:
                  '''
                  Public Key used to verify the Platform Owner Key Manifest.
                  Key Type: ECC NIST-P256 Curve.
                  This should be provisioned during the Platform Owner intra-role ownership transfer
                  process when the lifecycle state (LC) is PROD. Provisioning occurs via an Ownership Claim
                  operation after the previous Platform Owner completes a Relinquish operation.
                  '''
                isdigest: false
                iszer: false
                ismubi: false
                iskeymgr_creator: false
                iskeymgr_owner: false
                absorb: false
                inv_default: 0
                offset: 3592
              }
              {
                name: PLAT_OWNER_AUTH_SLOT3_UNLOCK4XFER_KEY_TYPE
                size: 4
                desc:
                  '''
                  Key usage type. One of the following 32-bit values defined
                  by the sigverify API:
                  - kSigverifyKeyTypeTest for manufacturing, testing and RMA keys.
                  Keys of this type can be used only in TEST_UNLOCKED* and RMA life
                  cycle states.
                  - kSigverifyKeyTypeProd for production keys.
                  Keys of this type can be used in all operational life cycle states, i.e.
                  states in which CPU execution is enabled.
                  - kSigverifyKeyTypeDev for development keys.
                  Keys of this type can be used only in the DEV life cycle state.
                  '''
                isdigest: false
                iszer: false
                ismubi: false
                iskeymgr_creator: false
                iskeymgr_owner: false
                absorb: false
                inv_default: 0
                offset: 3656
              }
              {
                name: PLAT_OWNER_AUTH_SLOT3_UNLOCK4XFER_KEY_ROLE
                size: 4
                desc:
                  '''
                  Key role that describes the kind of assets a key could sign.
                  This must be set to the `kSigverifyKeyRoleRelinquishOwnership` 32-bit
                  value as defined by the sigverify API.
                  '''
                isdigest: false
                iszer: false
                ismubi: false
                iskeymgr_creator: false
                iskeymgr_owner: false
                absorb: false
                inv_default: 0
                offset: 3660
              }
              {
                name: PLAT_OWNER_AUTH_SLOT3_UNLOCK4XFER_KEY
                size: 64
                desc:
                  '''
                  Public Key used to verify the Platform Owner Unlock Ownership firmware image.
                  Key Type: ECC NIST-P256 Curve.
                  This should be provisioned during the Platform Owner intra-role ownership transfer
                  process when the lifecycle state (LC) is PROD. Provisioning occurs via an Ownership Claim
                  operation after the previous Platform Owner completes a Relinquish operation.
                  '''
                isdigest: false
                iszer: false
                ismubi: false
                iskeymgr_creator: false
                iskeymgr_owner: false
                absorb: false
                inv_default: 0
                offset: 3664
              }
              {
                name: PLAT_OWNER_AUTH_SLOT3_DIGEST
                size: 8
                offset: 3728
                ismubi: false
                isdigest: true
                iszer: false
                inv_default: 2932316366930412108
                iskeymgr_creator: false
                iskeymgr_owner: false
              }
              {
                name: PLAT_OWNER_AUTH_SLOT3_ZER
                size: 8
                offset: 3736
                ismubi: false
                isdigest: false
                iszer: true
                inv_default: 0
                iskeymgr_creator: false
                iskeymgr_owner: false
              }
            ]
            desc: Software managed Platform Owner slot 3 partition.
            iskeymgr_creator: false
            iskeymgr_owner: false
            ignore_read_lock_in_rma: false
            size: 160
            offset: 3584
          }
          {
            name: EXT_NVM
            variant: Unbuffered
            absorb: false
            secret: false
            sw_digest: false
            hw_digest: false
            write_lock: None
            read_lock: CSR
            key_sel: NoKey
            integrity: false
            bkout_type: false
            zeroizable: true
            items:
            [
              {
                name: EXT_NVM_ANTIREPLAY_FRESHNESS_CNT
                size: 1024
                desc:
                  '''
                  Fully SW managed partition
                  1 bit (double bit allocated for redundancy - i.e. 2 physical bits for every logical bit) per day
                  assuming 10 year product lifecycle, allocating 8192 bits of freshness protection.
                  Implemented as thermometer encoding. Redundant bit programming & logical OR-ing managed by
                  software. Cannot be ECC protected since different bits in a fuse row are programmed at different times.
                  '''
                isdigest: false
                iszer: false
                ismubi: false
                iskeymgr_creator: false
                iskeymgr_owner: false
                absorb: false
                inv_default: 0
                offset: 3744
              }
              {
                name: EXT_NVM_ZER
                size: 8
                offset: 4768
                ismubi: false
                isdigest: false
                iszer: true
                inv_default: 0
                iskeymgr_creator: false
                iskeymgr_owner: false
              }
            ]
            desc: Anti-replay protection Strike Counters partition.
            iskeymgr_creator: false
            iskeymgr_owner: false
            ignore_read_lock_in_rma: false
            size: 1032
            offset: 3744
          }
          {
            name: ROM_PATCH
            variant: Unbuffered
            absorb: false
            secret: false
            sw_digest: true
            hw_digest: false
            write_lock: Digest
            read_lock: CSR
            key_sel: NoKey
            integrity: true
            bkout_type: false
            zeroizable: true
            items:
            [
              {
                name: ROM_PATCH_DATA
                size: 8192
                desc:
                  '''
                  Fully SW managed partition.
                  ROM patch section for signed ROM patches.
                  Each patch contains a header, a signature, the patch match/redirect configuration and the actual patch code.
                  Please refer to the Dragonfly ROM boot & patching specification for more details.
                  '''
                isdigest: false
                iszer: false
                ismubi: false
                iskeymgr_creator: false
                iskeymgr_owner: false
                absorb: false
                inv_default: 0
                offset: 4776
              }
              {
                name: ROM_PATCH_DIGEST
                size: 8
                offset: 12968
                ismubi: false
                isdigest: true
                iszer: false
                inv_default: 14592557388175589354
                iskeymgr_creator: false
                iskeymgr_owner: false
              }
              {
                name: ROM_PATCH_ZER
                size: 8
                offset: 12976
                ismubi: false
                isdigest: false
                iszer: true
                inv_default: 0
                iskeymgr_creator: false
                iskeymgr_owner: false
              }
            ]
            desc: ROM Patch Code section. May contain multiple signed ROM2 patches.
            iskeymgr_creator: false
            iskeymgr_owner: false
            ignore_read_lock_in_rma: false
            size: 8208
            offset: 4776
          }
          {
            name: SOC_FUSES_CP
            variant: Unbuffered
            absorb: false
            secret: false
            sw_digest: true
            hw_digest: false
            write_lock: Digest
            read_lock: CSR
            key_sel: NoKey
            integrity: true
            bkout_type: false
            items:
            [
              {
                name: SOC_FUSES_CP1_DATA
                size: 256
                isdigest: false
                iszer: false
                ismubi: false
                iskeymgr_creator: false
                iskeymgr_owner: false
                absorb: false
                inv_default: 0
                offset: 12984
              }
              {
                name: SOC_FUSES_CP2_DATA
                size: 128
                isdigest: false
                iszer: false
                ismubi: false
                iskeymgr_creator: false
                iskeymgr_owner: false
                absorb: false
                inv_default: 0
                offset: 13240
              }
              {
                name: SOC_FUSES_CP_DIGEST
                size: 8
                offset: 13368
                ismubi: false
                isdigest: true
                iszer: false
                inv_default: 8050338520295093693
                iskeymgr_creator: false
                iskeymgr_owner: false
              }
            ]
            desc: SoC fuses partition for the Chip Probe (CP) manufacturing stage.
            iskeymgr_creator: false
            iskeymgr_owner: false
            zeroizable: false
            ignore_read_lock_in_rma: false
            size: 392
            offset: 12984
          }
          {
            name: SOC_FUSES_FT
            variant: Unbuffered
            absorb: false
            secret: false
            sw_digest: true
            hw_digest: false
            write_lock: Digest
            read_lock: CSR
            key_sel: NoKey
            integrity: true
            bkout_type: false
            items:
            [
              {
                name: SOC_FUSES_FT1_DATA
                size: 384
                isdigest: false
                iszer: false
                ismubi: false
                iskeymgr_creator: false
                iskeymgr_owner: false
                absorb: false
                inv_default: 0
                offset: 13376
              }
              {
                name: SOC_FUSES_FT2_DATA
                size: 3840
                isdigest: false
                iszer: false
                ismubi: false
                iskeymgr_creator: false
                iskeymgr_owner: false
                absorb: false
                inv_default: 0
                offset: 13760
              }
              {
                name: SOC_FUSES_FT_DIGEST
                size: 8
                offset: 17600
                ismubi: false
                isdigest: true
                iszer: false
                inv_default: 2245725931179433842
                iskeymgr_creator: false
                iskeymgr_owner: false
              }
            ]
            desc: SoC fuses partition for the Factory Testing (FT) manufacturing stage.
            iskeymgr_creator: false
            iskeymgr_owner: false
            zeroizable: false
            ignore_read_lock_in_rma: false
            size: 4232
            offset: 13376
          }
          {
            name: SCRATCH_FUSES
            variant: Unbuffered
            absorb: true
            secret: false
            sw_digest: false
            hw_digest: false
            write_lock: None
            read_lock: CSR
            key_sel: NoKey
            integrity: true
            bkout_type: false
            zeroizable: true
            items:
            [
              {
                name: SCRATCH_FUSES_DATA
                absorb: true
                desc:
                  '''
                  Fully SW managed partition.
                  Unstructured, single item partition for any RoT firmware (runtime,
                  bootstrap, manufacturing) to use and organize freely.
                  '''
                size: 2392
                isdigest: false
                iszer: false
                ismubi: false
                iskeymgr_creator: false
                iskeymgr_owner: false
                inv_default: 0
                offset: 17608
              }
              {
                name: SCRATCH_FUSES_ZER
                size: 8
                offset: 20000
                ismubi: false
                isdigest: false
                iszer: true
                inv_default: 0
                iskeymgr_creator: false
                iskeymgr_owner: false
              }
            ]
            desc: Unstructured scratch data partition.
            iskeymgr_creator: false
            iskeymgr_owner: false
            ignore_read_lock_in_rma: false
            size: 2400
            offset: 17608
          }
          {
            name: HW_CFG0
            variant: Buffered
            secret: false
            sw_digest: false
            hw_digest: true
            write_lock: Digest
            read_lock: None
            key_sel: NoKey
            integrity: true
            bkout_type: true
            zeroizable: true
            skip_sw_header: true
            items:
            [
              {
                name: DEVICE_ID
                size: 32
                inv_default: 40117173308102545085356168480633505499540504862520500713288653871548071919464
                desc:
                  '''
                  Unique device identifier that is always exposed through the
                  lifecycle JTAG tap. See documentation on Device Identifiers.
                  '''
                isdigest: false
                iszer: false
                ismubi: false
                iskeymgr_creator: false
                iskeymgr_owner: false
                absorb: false
                offset: 20008
              }
              {
                name: HW_CFG0_DIGEST
                size: 8
                offset: 20040
                ismubi: false
                isdigest: true
                iszer: false
                inv_default: 15994060125354592494
                iskeymgr_creator: false
                iskeymgr_owner: false
              }
              {
                name: HW_CFG0_ZER
                size: 8
                offset: 20048
                ismubi: false
                isdigest: false
                iszer: true
                inv_default: 0
                iskeymgr_creator: false
                iskeymgr_owner: false
              }
            ]
            desc:
              '''
              Hardware configuration partition 0.
              This contains a device identifier.
              '''
            absorb: false
            iskeymgr_creator: false
            iskeymgr_owner: false
            ignore_read_lock_in_rma: false
            size: 48
            offset: 20008
          }
          {
            name: HW_CFG1
            variant: Buffered
            secret: false
            sw_digest: false
            hw_digest: true
            write_lock: Digest
            read_lock: None
            key_sel: NoKey
            integrity: true
            bkout_type: true
            zeroizable: true
            skip_sw_header: true
            items:
            [
              {
                name: EN_CSRNG_SW_APP_READ
                size: 1
                ismubi: true
                inv_default: 105
                desc:
                  '''
                  Enablement of CSRNG software application interface. A
                  kMultiBitBool8True value enables, while all other values
                  disable. Enablement is required to extract output from
                  CSRNG via software.
                  '''
                isdigest: false
                iszer: false
                iskeymgr_creator: false
                iskeymgr_owner: false
                absorb: false
                offset: 20056
              }
              {
                name: EN_SRAM_IFETCH
                size: 1
                ismubi: true
                inv_default: 105
                desc:
                  '''
                  Enablement of execute from SRAM switch in the sram_ctrl (see
                  EXEC CSR). A kMultiBitBool8True value enables, while all
                  other values disable.
                  '''
                isdigest: false
                iszer: false
                iskeymgr_creator: false
                iskeymgr_owner: false
                absorb: false
                offset: 20057
              }
              {
                name: HW_CFG1_DIGEST
                size: 8
                offset: 20064
                ismubi: false
                isdigest: true
                iszer: false
                inv_default: 9694113004490520906
                iskeymgr_creator: false
                iskeymgr_owner: false
              }
              {
                name: HW_CFG1_ZER
                size: 8
                offset: 20072
                ismubi: false
                isdigest: false
                iszer: true
                inv_default: 0
                iskeymgr_creator: false
                iskeymgr_owner: false
              }
            ]
            desc:
              '''
              Hardware configuration partition 1.
              This contains several hardware feature switches.
              '''
            absorb: false
            iskeymgr_creator: false
            iskeymgr_owner: false
            ignore_read_lock_in_rma: false
            size: 24
            offset: 20056
          }
          {
            name: HW_CFG2
            variant: Buffered
            secret: false
            sw_digest: false
            hw_digest: true
            write_lock: Digest
            read_lock: None
            key_sel: NoKey
            integrity: true
            bkout_type: true
            zeroizable: true
            items:
            [
              {
                name: SOC_DBG_STATE
                size: 4
                inv_default: 0
                desc:
                  '''
                  Multi-bit enable value for the SOC debug authorization.
                  SOC_DBG_STATE will be written twice in a device lifetime. The
                  values to be written are engineered in the same way as the LC_CTRL
                  state encoding words: the ECC encoding remains valid even after
                  writing the second value on top of the first.
                  The constants can be found in the lc_ctrl_state_pkg.sv package.
                  The programming order has to adhere to:
                  SOC_DBG_RAW -> SOC_DBG_PRE_PROD -> SOC_DBG_PROD.
                  Encoding:
                  SOC_DBG_RAW: this value is all-zeroes and will be the NOP state;
                  the LC controller will take precedence.
                  SOC_DBG_PRE_PROD: this is where the ROT will be in PROD state
                  but SOC will be in the pre-production unlock state
                  SOC_DBG_PROD: this is the state where the SOC moves to production,
                  and the challenge-response based authentication protocol is
                  required to unlock SOC debug features
                  '''
                isdigest: false
                iszer: false
                ismubi: false
                iskeymgr_creator: false
                iskeymgr_owner: false
                absorb: false
                offset: 20080
              }
              {
                name: MANUF_STATE
                size: 32
                inv_default: 104735823630885006896435419055152518946049592294862500793111622154345667968901
                desc: Field to capture the manufacturing state.
                isdigest: false
                iszer: false
                ismubi: false
                iskeymgr_creator: false
                iskeymgr_owner: false
                absorb: false
                offset: 20084
              }
              {
                name: HW_CFG2_DIGEST
                size: 8
                offset: 20120
                ismubi: false
                isdigest: true
                iszer: false
                inv_default: 6520999107440904866
                iskeymgr_creator: false
                iskeymgr_owner: false
              }
              {
                name: HW_CFG2_ZER
                size: 8
                offset: 20128
                ismubi: false
                isdigest: false
                iszer: true
                inv_default: 0
                iskeymgr_creator: false
                iskeymgr_owner: false
              }
            ]
            desc:
              '''
              Hardware configuration partition 2.
              This contains the SoC debug state and the manufacturing state.
              '''
            absorb: false
            iskeymgr_creator: false
            iskeymgr_owner: false
            ignore_read_lock_in_rma: false
            size: 56
            offset: 20080
          }
          {
            name: SECRET0
            variant: Buffered
            secret: true
            sw_digest: false
            hw_digest: true
            write_lock: Digest
            read_lock: Digest
            ignore_read_lock_in_rma: true
            key_sel: Secret0Key
            integrity: true
            bkout_type: false
            zeroizable: true
            skip_sw_header: true
            items:
            [
              {
                name: TEST_UNLOCK_TOKEN
                inv_default: 42146219275086284332081154515457931983
                size: 16
                isdigest: false
                iszer: false
                ismubi: false
                iskeymgr_creator: false
                iskeymgr_owner: false
                absorb: false
                offset: 20136
              }
              {
                name: TEST_EXIT_TOKEN
                inv_default: 241193388044955693821746483131132302114
                size: 16
                isdigest: false
                iszer: false
                ismubi: false
                iskeymgr_creator: false
                iskeymgr_owner: false
                absorb: false
                offset: 20152
              }
              {
                name: SECRET0_DIGEST
                size: 8
                offset: 20168
                ismubi: false
                isdigest: true
                iszer: false
                inv_default: 13418438502867544032
                iskeymgr_creator: false
                iskeymgr_owner: false
              }
              {
                name: SECRET0_ZER
                size: 8
                offset: 20176
                ismubi: false
                isdigest: false
                iszer: true
                inv_default: 0
                iskeymgr_creator: false
                iskeymgr_owner: false
              }
            ]
            desc:
              '''
              Secret partition 0.
              This contains TEST lifecycle unlock tokens.
              '''
            absorb: false
            iskeymgr_creator: false
            iskeymgr_owner: false
            size: 48
            offset: 20136
          }
          {
            name: SECRET1
            variant: Buffered
            secret: true
            sw_digest: false
            hw_digest: true
            write_lock: Digest
            read_lock: Digest
            ignore_read_lock_in_rma: true
            key_sel: Secret1Key
            integrity: true
            bkout_type: false
            zeroizable: true
            skip_sw_header: true
            items:
            [
              {
                name: SRAM_DATA_KEY_SEED
                inv_default: 49610584572420053792236730456054518552
                size: 16
                isdigest: false
                iszer: false
                ismubi: false
                iskeymgr_creator: false
                iskeymgr_owner: false
                absorb: false
                offset: 20184
              }
              {
                name: SECRET1_DIGEST
                size: 8
                offset: 20200
                ismubi: false
                isdigest: true
                iszer: false
                inv_default: 5791744465669227273
                iskeymgr_creator: false
                iskeymgr_owner: false
              }
              {
                name: SECRET1_ZER
                size: 8
                offset: 20208
                ismubi: false
                isdigest: false
                iszer: true
                inv_default: 0
                iskeymgr_creator: false
                iskeymgr_owner: false
              }
            ]
            desc:
              '''
              Secret partition 1.
              This contains the SRAM scrambling key seed.
              '''
            absorb: false
            iskeymgr_creator: false
            iskeymgr_owner: false
            size: 32
            offset: 20184
          }
          {
            name: SECRET2
            variant: Buffered
            secret: true
            sw_digest: false
            hw_digest: true
            write_lock: Digest
            read_lock: Digest
            ignore_read_lock_in_rma: true
            key_sel: Secret2Key
            integrity: true
            bkout_type: false
            zeroizable: true
            skip_sw_header: true
            items:
            [
              {
                name: RMA_TOKEN
                inv_default: 318948098383762964490193881142352172697
                size: 16
                isdigest: false
                iszer: false
                ismubi: false
                iskeymgr_creator: false
                iskeymgr_owner: false
                absorb: false
                offset: 20216
              }
              {
                name: CREATOR_ROOT_KEY_SHARE0
                inv_default: 34629914360704372211018394036838819133727768471239971144446686782216090585462
                size: 32
                iskeymgr_creator: true
                isdigest: false
                iszer: false
                ismubi: false
                iskeymgr_owner: false
                absorb: false
                offset: 20232
              }
              {
                name: CREATOR_ROOT_KEY_SHARE1
                inv_default: 1304928998077618167994330237584170289335028615580548538480488972898025704836
                size: 32
                iskeymgr_creator: true
                isdigest: false
                iszer: false
                ismubi: false
                iskeymgr_owner: false
                absorb: false
                offset: 20264
              }
              {
                name: CREATOR_SEED
                inv_default: 17833865895625802678504757898438306129490488436729400947978243968268591742052
                size: 32
                iskeymgr_creator: true
                isdigest: false
                iszer: false
                ismubi: false
                iskeymgr_owner: false
                absorb: false
                offset: 20296
              }
              {
                name: SECRET2_DIGEST
                size: 8
                offset: 20328
                ismubi: false
                isdigest: true
                iszer: false
                inv_default: 1794854062480160716
                iskeymgr_creator: false
                iskeymgr_owner: false
              }
              {
                name: SECRET2_ZER
                size: 8
                offset: 20336
                ismubi: false
                isdigest: false
                iszer: true
                inv_default: 0
                iskeymgr_creator: false
                iskeymgr_owner: false
              }
            ]
            desc:
              '''
              Secret partition 2.
              This contains RMA unlock token, creator root key, and creator seed.
              '''
            absorb: false
            iskeymgr_creator: true
            iskeymgr_owner: false
            size: 128
            offset: 20216
          }
          {
            name: SECRET3
            variant: Buffered
            secret: true
            sw_digest: false
            hw_digest: true
            write_lock: Digest
            read_lock: Digest
            key_sel: Secret3Key
            integrity: true
            bkout_type: false
            zeroizable: true
            skip_sw_header: true
            items:
            [
              {
                name: OWNER_SEED
                inv_default: 70686486377297932620694155829978992075095653265301635643322899792586608109306
                size: 32
                iskeymgr_owner: true
                isdigest: false
                iszer: false
                ismubi: false
                iskeymgr_creator: false
                absorb: false
                offset: 20344
              }
              {
                name: SECRET3_DIGEST
                size: 8
                offset: 20376
                ismubi: false
                isdigest: true
                iszer: false
                inv_default: 17482466783658110580
                iskeymgr_creator: false
                iskeymgr_owner: false
              }
              {
                name: SECRET3_ZER
                size: 8
                offset: 20384
                ismubi: false
                isdigest: false
                iszer: true
                inv_default: 0
                iskeymgr_creator: false
                iskeymgr_owner: false
              }
            ]
            desc:
              '''
              Secret partition 3.
              This contains the owner seed.
              '''
            absorb: false
            iskeymgr_creator: false
            iskeymgr_owner: true
            ignore_read_lock_in_rma: false
            size: 48
            offset: 20344
          }
          {
            name: LIFE_CYCLE
            variant: LifeCycle
            secret: false
            sw_digest: false
            hw_digest: false
            write_lock: None
            read_lock: None
            key_sel: NoKey
            integrity: true
            bkout_type: false
            skip_sw_header: true
            items:
            [
              {
                name: LC_TRANSITION_CNT
                inv_default: 14973992796729436808066378999705846639531905052544376352002892737561959261552710366946253675634166805643724298065935
                size: 48
                isdigest: false
                iszer: false
                ismubi: false
                iskeymgr_creator: false
                iskeymgr_owner: false
                absorb: false
                offset: 20392
              }
              {
                name: LC_STATE
                inv_default: 1740163610035578858103898302773429044443128827890610586479008287934284440493394280935669489663884
                size: 40
                isdigest: false
                iszer: false
                ismubi: false
                iskeymgr_creator: false
                iskeymgr_owner: false
                absorb: false
                offset: 20440
              }
            ]
            desc:
              '''
              Lifecycle partition.
              This contains lifecycle transition count and state. This partition
              cannot be locked since the life cycle state needs to advance to RMA
              in-field. Note that while this partition is not marked secret, it
              is not readable nor writeable via the DAI. Only the LC controller
              can access this partition, and even via the LC controller it is not
              possible to read the raw manufacturing life cycle state in encoded
              form, since that encoding is considered a netlist secret. The LC
              controller only exposes a decoded version of this state.
              '''
            absorb: false
            iskeymgr_creator: false
            iskeymgr_owner: false
            zeroizable: false
            ignore_read_lock_in_rma: false
            size: 88
            offset: 20392
          }
        ]
      }
    }
    {
      name: lc_ctrl
      type: lc_ctrl
      base_addrs:
      {
        regs:
        {
          hart: 0x30150000
        }
        dmi:
        {
          soc_dbg: 0x3000
        }
      }
      memory: {}
      param_list:
      [
        {
          name: RndCnstLcKeymgrDivInvalid
          desc: Diversification value used for all invalid life cycle states.
          type: lc_ctrl_pkg::lc_keymgr_div_t
          randcount: 128
          randtype: data
          name_top: RndCnstLcCtrlLcKeymgrDivInvalid
          default: 0x362730aca45340f2b0ee60f25e2cee80
          randwidth: 128
        }
        {
          name: RndCnstLcKeymgrDivTestUnlocked
          desc: Diversification value used for the TEST_UNLOCKED* life cycle states.
          type: lc_ctrl_pkg::lc_keymgr_div_t
          randcount: 128
          randtype: data
          name_top: RndCnstLcCtrlLcKeymgrDivTestUnlocked
          default: 0xa251609d5dda4a4ad8c83d397d1f83d0
          randwidth: 128
        }
        {
          name: RndCnstLcKeymgrDivDev
          desc: Diversification value used for the DEV life cycle state.
          type: lc_ctrl_pkg::lc_keymgr_div_t
          randcount: 128
          randtype: data
          name_top: RndCnstLcCtrlLcKeymgrDivDev
          default: 0x345aedbbb4d7aa719297d83ae6df7ca6
          randwidth: 128
        }
        {
          name: RndCnstLcKeymgrDivProduction
          desc: Diversification value used for the PROD/PROD_END life cycle states.
          type: lc_ctrl_pkg::lc_keymgr_div_t
          randcount: 128
          randtype: data
          name_top: RndCnstLcCtrlLcKeymgrDivProduction
          default: 0x2c4b0bd6ee484a7eafe9079b80932f7d
          randwidth: 128
        }
        {
          name: RndCnstLcKeymgrDivRma
          desc: Diversification value used for the RMA life cycle state.
          type: lc_ctrl_pkg::lc_keymgr_div_t
          randcount: 128
          randtype: data
          name_top: RndCnstLcCtrlLcKeymgrDivRma
          default: 0x9ef197ba49ceebede8f7a26b19372684
          randwidth: 128
        }
        {
          name: RndCnstInvalidTokens
          desc: Compile-time random bits used for invalid tokens in the token mux
          type: lc_ctrl_pkg::lc_token_mux_t
          randcount: 1024
          randtype: data
          name_top: RndCnstLcCtrlInvalidTokens
          default: 0xcdc4422c133b9d9a6699b6c77a29761f9598107c33b11ac5761c14981aeac9e28f9d016c02b80b1581ba47b081edad7956485909768ef3dba808cbc6d57fe7489f41549870395c90d9abf4e0f5ed5ba097b3ba3ccf06d21e513960c35528862db5cac22cb2a45ab2e047ce9e7c9aec58ac5c504382899fc90d110075ff2d2698
          randwidth: 1024
        }
      ]
    }
    {
      name: alert_handler
      type: alert_handler
      base_addrs:
      {
        null:
        {
          hart: 0x30160000
        }
      }
      memory: {}
      param_list:
      [
        {
          name: RndCnstLfsrSeed
          desc: Compile-time random bits for initial LFSR seed
          type: alert_handler_pkg::lfsr_seed_t
          randcount: 32
          randtype: data
          name_top: RndCnstAlertHandlerLfsrSeed
          default: 0x6fc60147
          randwidth: 32
        }
        {
          name: RndCnstLfsrPerm
          desc: Compile-time random permutation for LFSR output
          type: alert_handler_pkg::lfsr_perm_t
          randcount: 32
          randtype: perm
          name_top: RndCnstAlertHandlerLfsrPerm
          default: 0xf4b8ec7d09bd8593ec0bd1a212b293abc6a811bd
          randwidth: 160
        }
      ]
      template_type: alert_handler
    }
    {
      name: sram_ctrl_ret_aon
      type: sram_ctrl
      base_addrs:
      {
        regs:
        {
          hart: 0x30500000
        }
        ram:
        {
          hart: 0x30600000
        }
      }
      memory:
      {
        ram:
        {
          label: ram_ret_aon
          swaccess: rw
          data_intg_passthru: "true"
          exec: True
          byte_write: True
          size: 0x1000
        }
      }
      param_list:
      [
        {
          name: RndCnstSramKey
          desc: Compile-time random reset value for SRAM scrambling key.
          type: otp_ctrl_pkg::sram_key_t
          randcount: 128
          randtype: data
          name_top: RndCnstSramCtrlRetAonSramKey
          default: 0xb4d3dd5291dc19baab9bb3509c609680
          randwidth: 128
        }
        {
          name: RndCnstSramNonce
          desc: Compile-time random reset value for SRAM scrambling nonce.
          type: otp_ctrl_pkg::sram_nonce_t
          randcount: 128
          randtype: data
          name_top: RndCnstSramCtrlRetAonSramNonce
          default: 0x2e87c85822432d73c32bacac31c93158
          randwidth: 128
        }
        {
          name: RndCnstLfsrSeed
          desc: Compile-time random bits for initial LFSR seed
          type: sram_ctrl_pkg::lfsr_seed_t
          randcount: 64
          randtype: data
          name_top: RndCnstSramCtrlRetAonLfsrSeed
          default: 0x247f13392519995
          randwidth: 64
        }
        {
          name: RndCnstLfsrPerm
          desc: Compile-time random permutation for LFSR output
          type: sram_ctrl_pkg::lfsr_perm_t
          randcount: 64
          randtype: perm
          name_top: RndCnstSramCtrlRetAonLfsrPerm
          default: 0xdbc23c643fe3015c5589c9c98b45da352a54f67e982f03388d1024aceab437b74b8e7bb614647e7820687f9fc695f6a
          randwidth: 384
        }
      ]
    }
    {
      name: acc
      type: acc
      base_addrs:
      {
        null:
        {
          hart: 0x22100000
        }
      }
      memory: {}
      param_list:
      [
        {
          name: RndCnstUrndPrngSeed
          desc: Default seed of the PRNG used for URND.
          type: acc_pkg::urnd_prng_seed_t
          randcount: 256
          randtype: data
          name_top: RndCnstAccUrndPrngSeed
          default: 0x7fba1c57a496d09377df413b2b191272161213b80315a177c7516ecd4b002af6
          randwidth: 256
        }
        {
          name: RndCnstAccKey
          desc: Compile-time random reset value for IMem/DMem scrambling key.
          type: otp_ctrl_pkg::acc_key_t
          randcount: 128
          randtype: data
          name_top: RndCnstAccAccKey
          default: 0xb49253ad7151c8e8f1a51fd184abfa40
          randwidth: 128
        }
        {
          name: RndCnstAccNonce
          desc: Compile-time random reset value for IMem/DMem scrambling nonce.
          type: otp_ctrl_pkg::acc_nonce_t
          randcount: 64
          randtype: data
          name_top: RndCnstAccAccNonce
          default: 0xd2cd2d16f3d54d9d
          randwidth: 64
        }
      ]
    }
    {
      name: aes
      type: aes
      base_addrs:
      {
        null:
        {
          hart: 0x21100000
        }
      }
      memory: {}
      param_list:
      [
        {
          name: RndCnstClearingLfsrSeed
          desc: Default seed of the PRNG used for register clearing.
          type: aes_pkg::clearing_lfsr_seed_t
          randcount: 64
          randtype: data
          name_top: RndCnstAesClearingLfsrSeed
          default: 0xa75ebed27fdcf8d1
          randwidth: 64
        }
        {
          name: RndCnstClearingLfsrPerm
          desc: Permutation applied to the LFSR of the PRNG used for clearing.
          type: aes_pkg::clearing_lfsr_perm_t
          randcount: 64
          randtype: perm
          name_top: RndCnstAesClearingLfsrPerm
          default: 0x6bf7a2aa1b9700c238c0b468c69f27506903cb54d535f74e118b1c9878f9590ebdef36ed25217406b6763f70af97e2a0
          randwidth: 384
        }
        {
          name: RndCnstClearingSharePerm
          desc: Permutation applied to the clearing PRNG output for clearing the second share of registers.
          type: aes_pkg::clearing_lfsr_perm_t
          randcount: 64
          randtype: perm
          name_top: RndCnstAesClearingSharePerm
          default: 0x56e702023a418b52201bd38329a45def2f132effe194750db525b0e8fadbcfe6241197cc178d17df142a9b69f925ea2c
          randwidth: 384
        }
        {
          name: RndCnstMaskingLfsrSeed
          desc: Default seed of the PRNG used for masking.
          type: aes_pkg::masking_lfsr_seed_t
          randcount: 288
          randtype: data
          name_top: RndCnstAesMaskingLfsrSeed
          default: 0xbcadeab4279ab5aab57e7e674dfb493771d9122b5be0cc21f042ceb1a1ae71a7671b30f5
          randwidth: 288
        }
        {
          name: RndCnstMaskingLfsrPerm
          desc: Permutation applied to the output of the PRNG used for masking.
          type: aes_pkg::masking_lfsr_perm_t
          randcount: 160
          randtype: perm
          name_top: RndCnstAesMaskingLfsrPerm
          default: 0x834d718e47131628253310184b5c4807606444147d4f9346863b7843618d825f126c3463450f9c8b1d321e739954845d2b818c968985309a8f505a1a2d6d6b6e3197390e1f4c2270059b8a0c557b5e69205b3a37409f277a563e389d2f870423911b669e5990003d6a17012e29199453090b0358673695066f082a926865493c5102772c747e763f7f41577935751c8026520d15980a4e246272884a117c4221
          randwidth: 1280
        }
      ]
    }
    {
      name: kmac
      type: kmac
      base_addrs:
      {
        null:
        {
          hart: 0x21120000
        }
      }
      memory: {}
      param_list:
      [
        {
          name: RndCnstLfsrSeed
          desc: Compile-time random data for PRNG default seed
          type: kmac_pkg::lfsr_seed_t
          randcount: 288
          randtype: data
          name_top: RndCnstKmacLfsrSeed
          default: 0xc0511e4a008ff9b0afbd938a4fc64b63243e286f90f55031a6f3f5c5df91521ff989f25f
          randwidth: 288
        }
        {
          name: RndCnstLfsrPerm
          desc: Compile-time random permutation for PRNG output
          type: kmac_pkg::lfsr_perm_t
          randcount: 800
          randtype: perm
          name_top: RndCnstKmacLfsrPerm
          default: 0xa71975d98430122b9d0d1f27c4ba4d7665ba3513ba66624ae38b6636cc01288197c92f012b919a46bf6127016e39ca82d43172dd5665879ec12be5d87b6db02c609d5acaf70e2aa27140289514f02622ac8b01d426c28c89aa61582d613655798530a652b798a21072a9319401e976a5317f137409d19d635011f906fa12a78a69b431674381045b4423ea16a5eb021c5673a827295d3d8415b23e0453c7d08d70c5c95ea66481d7e1ee6aef579cc738c174fe184c95c0b4a39b02aa7da8c2e0a62005c16177766b05888a422f068037786cb2c5463a7383de532c79392a034d8da7a4a83a2c75d83348c1a45183d6454cc48b2a625f2e1686ee7be3514824a6cd44debfa39f10d9646e55e53687aedfb5bc9797db236d9693ad05df035421c37ec8b8ad50eefca10ec232938f1ba584a5374772b21076f1756e9986d49032f4569aa53a88a186bab9191a65dc506e864e5a4a47961d15449a4416b2b4378084581ef6b1d2018ee545e71a3da630e9d0bc8f3f6a84ed2516c340213a458960b9c44717a07cd53add255311c7626262f8095b0561730d6838cef71facd215c79a6eb1eec5a2586475ae96af32069435d919fa20b062b8a418085594442b46d2b7a142081097d948346fb138bb42a594e5a75e14188ed1a3169725033a243609eb038686f6c33cdb654eda3e6e6bfda536a376eed82900a1d2956f1c5145021fe8a8799b604e16252352e034c0deb3e6e1331b3bcb4ac50c84e303b65c155d406cbc1c23b2ea112189e050b2bfab78b8624d8d9735f3ada49671e00ccbd3350131846b02401c4008e58c41b1515dfd3f023a59712988374c3d81590362767dc599bce955924ad0224a115b6482b824f451ad13cf0b754a1a9fac431290aea5aa70663065899e8907a0e09ba0473b928019677c10fe4a85da8de21851263eb51110f549f93d06f7fc7d594bf875743424427d1ac00b12e12d2e4b7aaa3124e655f61f5d505708cfc1e149e9478ead3a2c78ba1a342d95202a5c20b36df1ea609459e0c77e3f86a2a57cf1aad799ca383de0b07a282a6a1272158ca56c3c1062f018d87673e6d0083a41c159a13e67da464d315a2c24a54394716730077845a280cca9d26239945cad2ab1af510dcbc6ecace5025600602be979bebb71a834ae810b629f1c072065c24c78e098200d9fd5512eba7f225485f59f6bcb1ace286ccb11b1aa54c982485f839018e27c099669a27b08932847325dc24546a8b1f0f97f2404903ef01613822ef2ae20155dd66d43071a856a41322b0c6757bc614592c43c0ad77f8c43cadf4d0ce4b2af2f9c87aa790f0643fdc13ec322aead309667913d6fe34b72640b30d3aa3d3baef6e02742267614e6b52c9100afc24f80fc6d4790e178d66813549e21
          randwidth: 8000
        }
        {
          name: RndCnstBufferLfsrSeed
          desc: Compile-time random data for PRNG buffer default seed
          type: kmac_pkg::buffer_lfsr_seed_t
          randcount: 800
          randtype: data
          name_top: RndCnstKmacBufferLfsrSeed
          default: 0x145326741f804e3c3a3451469c6118fa23bc32e428ad2be2584fe8d5491fa8e7f19aaa4133ad0d2704702ae2ff9d9849fcb59874cddc9cbc645d9e02a96b9980911844d3c74de85e05164b829d484bd447c9d7611999ca523b11575a82d625ea331f0dd0
          randwidth: 800
        }
        {
          name: RndCnstMsgPerm
          desc: Compile-time random permutation for LFSR Message output
          type: kmac_pkg::msg_perm_t
          randcount: 64
          randtype: perm
          name_top: RndCnstKmacMsgPerm
          default: 0xaf01b9e32eda319065bc80b62e1dc782de8fa1c41517cd7ebb40f34ce7f1a4d6d6b3f90af442406148e29d1497a9d99e
          randwidth: 384
        }
      ]
    }
    {
      name: keymgr_dpe
      type: keymgr_dpe
      base_addrs:
      {
        null:
        {
          hart: 0x21140000
        }
      }
      memory: {}
      param_list:
      [
        {
          name: RndCnstLfsrSeed
          desc: Compile-time random bits for initial LFSR seed
          type: keymgr_pkg::lfsr_seed_t
          randcount: 64
          randtype: data
          name_top: RndCnstKeymgrDpeLfsrSeed
          default: 0x1d6ec345718e6e72
          randwidth: 64
        }
        {
          name: RndCnstLfsrPerm
          desc: Compile-time random permutation for LFSR output
          type: keymgr_pkg::lfsr_perm_t
          randcount: 64
          randtype: perm
          name_top: RndCnstKeymgrDpeLfsrPerm
          default: 0xb0699333d6f03ea577bf48fa227a4212541d7b8af57d459960e80b271ba803373f6bbe51b62c8a343841f241c55fed92
          randwidth: 384
        }
        {
          name: RndCnstRandPerm
          desc: Compile-time random permutation for entropy used in share overriding
          type: keymgr_pkg::rand_perm_t
          randcount: 32
          randtype: perm
          name_top: RndCnstKeymgrDpeRandPerm
          default: 0x8dd1c404954c8fe7cd7397dacd80bad11b64bad
          randwidth: 160
        }
        {
          name: RndCnstRevisionSeed
          desc: Compile-time random bits for revision seed
          type: keymgr_pkg::seed_t
          randcount: 256
          randtype: data
          name_top: RndCnstKeymgrDpeRevisionSeed
          default: 0xffd7e8265faf402c8dbee7833f8128f587ee8a3b05767c77806068f2725a3c40
          randwidth: 256
        }
        {
          name: RndCnstSoftOutputSeed
          desc: Compile-time random bits for software generation seed
          type: keymgr_pkg::seed_t
          randcount: 256
          randtype: data
          name_top: RndCnstKeymgrDpeSoftOutputSeed
          default: 0xac8feb4f2302c232c482d07b560a3d678fb9a9dc420a1339b243bb28853b19b5
          randwidth: 256
        }
        {
          name: RndCnstHardOutputSeed
          desc: Compile-time random bits for hardware generation seed
          type: keymgr_pkg::seed_t
          randcount: 256
          randtype: data
          name_top: RndCnstKeymgrDpeHardOutputSeed
          default: 0xc399d4da9b067ed9be1d5753ffd02f20f4e525164dcff3cb4e007daccf0a553e
          randwidth: 256
        }
        {
          name: RndCnstAesSeed
          desc: Compile-time random bits for generation seed when aes destination selected
          type: keymgr_pkg::seed_t
          randcount: 256
          randtype: data
          name_top: RndCnstKeymgrDpeAesSeed
          default: 0x45bab60fd530ae84156d37cc68063276f9e85faee129ae80f5b440dc77964912
          randwidth: 256
        }
        {
          name: RndCnstKmacSeed
          desc: Compile-time random bits for generation seed when kmac destination selected
          type: keymgr_pkg::seed_t
          randcount: 256
          randtype: data
          name_top: RndCnstKeymgrDpeKmacSeed
          default: 0x7ec56c7b0e9645bf231b5b37b8c5559aee0d0e2f2dab7d371048b9f8db4f3775
          randwidth: 256
        }
        {
          name: RndCnstAccSeed
          desc: Compile-time random bits for generation seed when acc destination selected
          type: keymgr_pkg::seed_t
          randcount: 256
          randtype: data
          name_top: RndCnstKeymgrDpeAccSeed
          default: 0x8860ff09d90eece3c2f34229dd0318de05cfb093c70d4b54dc8afd1f07532671
          randwidth: 256
        }
        {
          name: RndCnstDmaSeed
          desc: Compile-time random bits for generation seed when dma destination selected
          type: keymgr_pkg::seed_t
          randcount: 256
          randtype: data
          name_top: RndCnstKeymgrDpeDmaSeed
          default: 0xeb83c820e1f1eaa3a18ad34d471b199cfd72b03fa6bedb61b505c2e545c708d5
          randwidth: 256
        }
        {
          name: RndCnstNoneSeed
          desc: Compile-time random bits for generation seed when no destination selected
          type: keymgr_pkg::seed_t
          randcount: 256
          randtype: data
          name_top: RndCnstKeymgrDpeNoneSeed
          default: 0x5fc11abcf2e75091bf86783e6a04bf53b6df5d93e4c8a20b7da9320c6d31e224
          randwidth: 256
        }
      ]
    }
    {
      name: csrng
      type: csrng
      base_addrs:
      {
        null:
        {
          hart: 0x21150000
        }
      }
      memory: {}
      param_list:
      [
        {
          name: RndCnstCsKeymgrDivNonProduction
          desc: Compile-time random bits for csrng state group diversification value
          type: csrng_pkg::cs_keymgr_div_t
          randcount: 384
          randtype: data
          name_top: RndCnstCsrngCsKeymgrDivNonProduction
          default: 0x35a360e9f49e943c6df7a058352e5ee54f3d6cb28edb47b15f73cfae197dc3f9534a87145d40138d0daa41d0efe0910f
          randwidth: 384
        }
        {
          name: RndCnstCsKeymgrDivProduction
          desc: Compile-time random bits for csrng state group diversification value
          type: csrng_pkg::cs_keymgr_div_t
          randcount: 384
          randtype: data
          name_top: RndCnstCsrngCsKeymgrDivProduction
          default: 0x221c4f25a8801439adc672fbb9d5b077f2cd4011ec5d83762867204336105d80c00220f1da1d3249b8b27f540d01c612
          randwidth: 384
        }
      ]
    }
    {
      name: sram_ctrl_main
      type: sram_ctrl
      base_addrs:
      {
        regs:
        {
          hart: 0x211c0000
        }
        ram:
        {
          hart: 0x10000000
        }
      }
      memory:
      {
        ram:
        {
          label: ram_main
          swaccess: rw
          data_intg_passthru: "true"
          exec: True
          byte_write: True
          size: 0x10000
        }
      }
      param_list:
      [
        {
          name: RndCnstSramKey
          desc: Compile-time random reset value for SRAM scrambling key.
          type: otp_ctrl_pkg::sram_key_t
          randcount: 128
          randtype: data
          name_top: RndCnstSramCtrlMainSramKey
          default: 0x6736232f991343079175c6a3f36d389b
          randwidth: 128
        }
        {
          name: RndCnstSramNonce
          desc: Compile-time random reset value for SRAM scrambling nonce.
          type: otp_ctrl_pkg::sram_nonce_t
          randcount: 128
          randtype: data
          name_top: RndCnstSramCtrlMainSramNonce
          default: 0xd5d0a06e314f7e0efdc7b7970a3ea735
          randwidth: 128
        }
        {
          name: RndCnstLfsrSeed
          desc: Compile-time random bits for initial LFSR seed
          type: sram_ctrl_pkg::lfsr_seed_t
          randcount: 64
          randtype: data
          name_top: RndCnstSramCtrlMainLfsrSeed
          default: 0x116a0c6b28f2300d
          randwidth: 64
        }
        {
          name: RndCnstLfsrPerm
          desc: Compile-time random permutation for LFSR output
          type: sram_ctrl_pkg::lfsr_perm_t
          randcount: 64
          randtype: perm
          name_top: RndCnstSramCtrlMainLfsrPerm
          default: 0x722174aefa7935b24ec368283d294747513752ce8caa67c309a60607186343c5732ddb56ee44ff657e2e02723e2b27bd
          randwidth: 384
        }
      ]
    }
    {
      name: sram_ctrl_mbox
      type: sram_ctrl
      base_addrs:
      {
        regs:
        {
          hart: 0x211d0000
        }
        ram:
        {
          hart: 0x11000000
        }
      }
      memory:
      {
        ram:
        {
          label: ram_mbox
          swaccess: rw
          data_intg_passthru: "true"
          exec: False
          byte_write: True
          size: 0x1000
        }
      }
      param_list:
      [
        {
          name: RndCnstSramKey
          desc: Compile-time random reset value for SRAM scrambling key.
          type: otp_ctrl_pkg::sram_key_t
          randcount: 128
          randtype: data
          name_top: RndCnstSramCtrlMboxSramKey
          default: 0xc6653cda8e066b989fb2bd83beadcf1a
          randwidth: 128
        }
        {
          name: RndCnstSramNonce
          desc: Compile-time random reset value for SRAM scrambling nonce.
          type: otp_ctrl_pkg::sram_nonce_t
          randcount: 128
          randtype: data
          name_top: RndCnstSramCtrlMboxSramNonce
          default: 0xb871270cc1e537545255eef8bbc56b20
          randwidth: 128
        }
        {
          name: RndCnstLfsrSeed
          desc: Compile-time random bits for initial LFSR seed
          type: sram_ctrl_pkg::lfsr_seed_t
          randcount: 64
          randtype: data
          name_top: RndCnstSramCtrlMboxLfsrSeed
          default: 0x6e008162473ae6cb
          randwidth: 64
        }
        {
          name: RndCnstLfsrPerm
          desc: Compile-time random permutation for LFSR output
          type: sram_ctrl_pkg::lfsr_perm_t
          randcount: 64
          randtype: perm
          name_top: RndCnstSramCtrlMboxLfsrPerm
          default: 0x2a3013e072729c1d3d8aa22cbd09921957daf9dc607b05055a9fe8e61f0f2ee11c60d0c2457325ecedf3dadeab65b935
          randwidth: 384
        }
      ]
    }
    {
      name: rom_ctrl0
      type: rom_ctrl
      base_addrs:
      {
        rom:
        {
          hart: 0x00008000
        }
        regs:
        {
          hart: 0x211e0000
        }
      }
      memory:
      {
        rom:
        {
          label: rom0
          swaccess: ro
          data_intg_passthru: True
          exec: True
          byte_write: False
          size: 0x8000
        }
      }
      param_list:
      [
        {
          name: RndCnstScrNonce
          desc: Fixed nonce used for address / data scrambling
          type: bit [63:0]
          randcount: 64
          randtype: data
          name_top: RndCnstRomCtrl0ScrNonce
          default: 0x9d3cd85feb1ee319
          randwidth: 64
        }
        {
          name: RndCnstScrKey
          desc: Randomised constant used as a scrambling key for ROM data
          type: bit [127:0]
          randcount: 128
          randtype: data
          name_top: RndCnstRomCtrl0ScrKey
          default: 0x926be21c682953b498f0978818db9932
          randwidth: 128
        }
      ]
    }
    {
      name: rom_ctrl1
      type: rom_ctrl
      base_addrs:
      {
        rom:
        {
          hart: 0x00020000
        }
        regs:
        {
          hart: 0x211e1000
        }
      }
      memory:
      {
        rom:
        {
          label: rom1
          swaccess: ro
          data_intg_passthru: True
          exec: True
          byte_write: False
          size: 0x10000
        }
      }
      param_list:
      [
        {
          name: RndCnstScrNonce
          desc: Fixed nonce used for address / data scrambling
          type: bit [63:0]
          randcount: 64
          randtype: data
          name_top: RndCnstRomCtrl1ScrNonce
          default: 0xd6137cb3fbd79c14
          randwidth: 64
        }
        {
          name: RndCnstScrKey
          desc: Randomised constant used as a scrambling key for ROM data
          type: bit [127:0]
          randcount: 128
          randtype: data
          name_top: RndCnstRomCtrl1ScrKey
          default: 0x73b06b9f20a29eabfcbbc16b35164d75
          randwidth: 128
        }
      ]
    }
    {
      name: dma
      type: dma
      base_addrs:
      {
        null:
        {
          hart: 0x22010000
        }
      }
      memory: {}
      param_list:
      [
        {
          name: RndCnstClearingLfsrSeed
          desc: Default seed of the inline-AES PRNG used for register clearing.
          type: aes_pkg::clearing_lfsr_seed_t
          randcount: 64
          randtype: data
          name_top: RndCnstDmaClearingLfsrSeed
          default: 0xebc2e3b50aefa1cd
          randwidth: 64
        }
        {
          name: RndCnstClearingLfsrPerm
          desc: Permutation applied to the LFSR of the inline-AES clearing PRNG.
          type: aes_pkg::clearing_lfsr_perm_t
          randcount: 64
          randtype: perm
          name_top: RndCnstDmaClearingLfsrPerm
          default: 0x88bdec0ba7d7fdc86eacdbda450a38ecace6c8f0d6789187a5b8f64bcd14335f9392017966ac009413889c477d558b71
          randwidth: 384
        }
        {
          name: RndCnstClearingSharePerm
          desc: Permutation applied to the clearing PRNG output for clearing the second share.
          type: aes_pkg::clearing_lfsr_perm_t
          randcount: 64
          randtype: perm
          name_top: RndCnstDmaClearingSharePerm
          default: 0x3dcb03661a784f05729c41f12cfaebc52366aa7bf1db4f7ecccc9f0b0e08928f8e6856b7599640a9c5847458eb54d7a
          randwidth: 384
        }
        {
          name: RndCnstMaskingLfsrSeed
          desc: Default seed of the inline-AES PRNG used for masking.
          type: aes_pkg::masking_lfsr_seed_t
          randcount: 288
          randtype: data
          name_top: RndCnstDmaMaskingLfsrSeed
          default: 0xf75d37f28396b53d310d4457746bff3406c193b6db9883cda8c2d0dd65578d173d15e674
          randwidth: 288
        }
        {
          name: RndCnstMaskingLfsrPerm
          desc: Permutation applied to the output of the inline-AES masking PRNG.
          type: aes_pkg::masking_lfsr_perm_t
          randcount: 160
          randtype: perm
          name_top: RndCnstDmaMaskingLfsrPerm
          default: 0x512b820f343b5d11029e742c8c365f864d4398281f372f6077507899101d737a0b8d6d17814f01408e722026568a447d324923891896853d7c667b5a29056f9146353f71169497686b848862522d4c486a5c4b5e191e591a3e769d126e63800e4a6c4e2490302192709f139c54337f690a642279385587580403650942003c4775416708145b2a9a3a2e159b25391c8327538b1b610d4506957e9331570c8f07
          randwidth: 1280
        }
      ]
    }
    {
      name: rv_core_ibex
      type: rv_core_ibex
      base_addrs:
      {
        cfg:
        {
          hart: 0x211f0000
        }
      }
      memory: {}
      param_list:
      [
        {
          name: RndCnstLfsrSeed
          desc: Default seed of the PRNG used for random instructions.
          type: ibex_pkg::lfsr_seed_t
          randcount: 32
          randtype: data
          name_top: RndCnstRvCoreIbexLfsrSeed
          default: 0x9537750d
          randwidth: 32
        }
        {
          name: RndCnstLfsrPerm
          desc: Permutation applied to the LFSR of the PRNG used for random instructions.
          type: ibex_pkg::lfsr_perm_t
          randcount: 32
          randtype: perm
          name_top: RndCnstRvCoreIbexLfsrPerm
          default: 0xc37f164883f1742b85c7ad10fe6edd829260666b
          randwidth: 160
        }
        {
          name: RndCnstIbexKeyDefault
          desc: Default icache scrambling key
          type: logic [ibex_pkg::SCRAMBLE_KEY_W-1:0]
          randcount: 128
          randtype: data
          name_top: RndCnstRvCoreIbexIbexKeyDefault
          default: 0x849fa1d7a18f21a66540109bba8c96e7
          randwidth: 128
        }
        {
          name: RndCnstIbexNonceDefault
          desc: Default icache scrambling nonce
          type: logic [ibex_pkg::SCRAMBLE_NONCE_W-1:0]
          randcount: 64
          randtype: data
          name_top: RndCnstRvCoreIbexIbexNonceDefault
          default: 0xf370be9d9c3de579
          randwidth: 64
        }
      ]
      template_type: rv_core_ibex
    }
  ]
}
