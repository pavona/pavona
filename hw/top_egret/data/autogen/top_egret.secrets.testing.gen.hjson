// Copyright lowRISC contributors (OpenTitan project).
// Licensed under the Apache License, Version 2.0, see LICENSE for details.
// SPDX-License-Identifier: Apache-2.0
//
// ------------------- W A R N I N G: A U T O - G E N E R A T E D   C O D E !! -------------------//
// PLEASE DO NOT HAND-EDIT THIS FILE. IT HAS BEEN AUTO-GENERATED WITH THE FOLLOWING COMMAND:
// util/topgen.py -t hw/top_egret/data/top_egret.hjson
//                -o hw/top_egret/
{
  seed:
  {
    topgen_seed:
    {
      seed_mode: testing
      value: 1017106219537032642877583828875051302543807092889754935647094601236425074047
    }
    otp_img_seed:
    {
      seed_mode: testing
      value: 52408960416235844780753299194502148156786072650816676092165912261205302331741
    }
    lc_ctrl_seed:
    {
      seed_mode: testing
      value: 40182201019264397688411770949626922549663256047001778394918990008320537410392
    }
  }
  module:
  [
    {
      name: otp_ctrl
      type: otp_ctrl
      base_addrs:
      {
        core:
        {
          hart: 0x40130000
        }
      }
      memory: {}
      param_list:
      [
        {
          name: RndCnstLfsrSeed
          desc: Compile-time random bits for initial LFSR seed
          type: otp_ctrl_top_specific_pkg::lfsr_seed_t
          randcount: 40
          randtype: data
          name_top: RndCnstOtpCtrlLfsrSeed
          default: 0xbad605bb69
          randwidth: 40
        }
        {
          name: RndCnstLfsrPerm
          desc: Compile-time random permutation for LFSR output
          type: otp_ctrl_top_specific_pkg::lfsr_perm_t
          randcount: 40
          randtype: perm
          name_top: RndCnstOtpCtrlLfsrPerm
          default: 0x79f30e48484b4640c62251406673c94e00948958cd61d5c75816d072629a
          randwidth: 240
        }
        {
          name: RndCnstScrmblKeyInit
          desc: Compile-time random permutation for scrambling key/nonce register reset value
          type: otp_ctrl_top_specific_pkg::scrmbl_key_init_t
          randcount: 256
          randtype: data
          name_top: RndCnstOtpCtrlScrmblKeyInit
          default: 0x5ce4ee55b032c07a29b920b7953e485f23ad102c6a0efce9f0ec4c712146a4ab
          randwidth: 256
        }
        {
          name: RndCnstScrmblKey0
          desc: Compile-time scrambling key
          type: otp_ctrl_top_specific_pkg::key_t
          randcount: 128
          randtype: extdata
          name_top: RndCnstOtpCtrlScrmblKey0
          default: 0x8e023b1e052dac1e0fcebeac537edc
          randwidth: 128
        }
        {
          name: RndCnstScrmblKey1
          desc: Compile-time scrambling key
          type: otp_ctrl_top_specific_pkg::key_t
          randcount: 128
          randtype: extdata
          name_top: RndCnstOtpCtrlScrmblKey1
          default: 0x7848da13345040c295fcbd76684e7170
          randwidth: 128
        }
        {
          name: RndCnstScrmblKey2
          desc: Compile-time scrambling key
          type: otp_ctrl_top_specific_pkg::key_t
          randcount: 128
          randtype: extdata
          name_top: RndCnstOtpCtrlScrmblKey2
          default: 0x57af03288e6c3c383a73e698950bfab6
          randwidth: 128
        }
        {
          name: RndCnstScrmblKey3
          desc: Compile-time scrambling key
          type: otp_ctrl_top_specific_pkg::key_t
          randcount: 128
          randtype: extdata
          name_top: RndCnstOtpCtrlScrmblKey3
          default: 0x9acf416ad5455d1dea1ea059dc5c584c
          randwidth: 128
        }
        {
          name: RndCnstDigestConst0
          desc: Compile-time digest const
          type: otp_ctrl_top_specific_pkg::digest_const_t
          randcount: 128
          randtype: extdata
          name_top: RndCnstOtpCtrlDigestConst0
          default: 0x74e7b5c15957663ac0a5a56f968fd7e9
          randwidth: 128
        }
        {
          name: RndCnstDigestConst1
          desc: Compile-time digest const
          type: otp_ctrl_top_specific_pkg::digest_const_t
          randcount: 128
          randtype: extdata
          name_top: RndCnstOtpCtrlDigestConst1
          default: 0x7a827e95a7385b32c02abd645fc814bc
          randwidth: 128
        }
        {
          name: RndCnstDigestConst2
          desc: Compile-time digest const
          type: otp_ctrl_top_specific_pkg::digest_const_t
          randcount: 128
          randtype: extdata
          name_top: RndCnstOtpCtrlDigestConst2
          default: 0xfe6728d0d0879ec62214d76208e9943a
          randwidth: 128
        }
        {
          name: RndCnstDigestConst3
          desc: Compile-time digest const
          type: otp_ctrl_top_specific_pkg::digest_const_t
          randcount: 128
          randtype: extdata
          name_top: RndCnstOtpCtrlDigestConst3
          default: 0xe17e956c21b003d0bcb1cbcd1eb02317
          randwidth: 128
        }
        {
          name: RndCnstDigestIV0
          desc: Compile-time digest initial vector
          type: otp_ctrl_top_specific_pkg::digest_iv_t
          randcount: 64
          randtype: extdata
          name_top: RndCnstOtpCtrlDigestIV0
          default: 0x99e3e946397824f3
          randwidth: 64
        }
        {
          name: RndCnstDigestIV1
          desc: Compile-time digest initial vector
          type: otp_ctrl_top_specific_pkg::digest_iv_t
          randcount: 64
          randtype: extdata
          name_top: RndCnstOtpCtrlDigestIV1
          default: 0x8071ef1bff0c99f0
          randwidth: 64
        }
        {
          name: RndCnstDigestIV2
          desc: Compile-time digest initial vector
          type: otp_ctrl_top_specific_pkg::digest_iv_t
          randcount: 64
          randtype: extdata
          name_top: RndCnstOtpCtrlDigestIV2
          default: 0xbc1cfcff9f3e4cd4
          randwidth: 64
        }
        {
          name: RndCnstDigestIV3
          desc: Compile-time digest initial vector
          type: otp_ctrl_top_specific_pkg::digest_iv_t
          randcount: 64
          randtype: extdata
          name_top: RndCnstOtpCtrlDigestIV3
          default: 0x43242540d2120889
          randwidth: 64
        }
        {
          name: RndCnstPartInvDefault
          desc: OTP invalid partition default for buffered partitions
          type: logic [16383:0]
          randcount: 16384
          randtype: extdata
          name_top: RndCnstOtpCtrlPartInvDefault
          default:
          [
            {
              size: 704
              items:
              [
                {
                  size: 320
                  inv_default: 150724158863578290761376796642879324047970044817803993230695865344826642621771004974996689303386
                }
                {
                  size: 384
                  inv_default: 6707296131048348035660209850454458516403716907741954216822891807334833183171263528798563328586680206667318424192181
                }
              ]
            }
            {
              size: 384
              items:
              [
                {
                  size: 64
                  inv_default: 0
                }
                {
                  size: 64
                  inv_default: 5776996463561863949
                }
                {
                  size: 256
                  inv_default: 46917961507141145256060626454085849401363337700765221407992884200406625985337
                }
              ]
            }
            {
              size: 960
              items:
              [
                {
                  size: 64
                  inv_default: 17765946314086229411
                }
                {
                  size: 256
                  inv_default: 42840131334136411941200644947425579008419079534194068434596656023607238656790
                }
                {
                  size: 256
                  inv_default: 33599205987092681210239649990958622833804933314610392317109421837165274603539
                }
                {
                  size: 256
                  inv_default: 92348881548169349828605117641018822276568973017337749653532230513078504803567
                }
                {
                  size: 128
                  inv_default: 130971651290035026448304299560793978178
                }
              ]
            }
            {
              size: 704
              items:
              [
                {
                  size: 64
                  inv_default: 18410855119173665658
                }
                {
                  size: 128
                  inv_default: 334671433878751700697199779069205613746
                }
                {
                  size: 256
                  inv_default: 7536910898370239450524093328085871963862640062161248607096610222518662706945
                }
                {
                  size: 256
                  inv_default: 23531955425096136348941735642650773479001928178605645757494297030518339325231
                }
              ]
            }
            {
              size: 320
              items:
              [
                {
                  size: 64
                  inv_default: 5835184937972759951
                }
                {
                  size: 128
                  inv_default: 335469059873213918850882942343750995942
                }
                {
                  size: 128
                  inv_default: 230748029623541578864187550162391519735
                }
              ]
            }
            {
              size: 128
              items:
              [
                {
                  size: 64
                  inv_default: 13248414165649443033
                }
                {
                  comment: unallocated space
                  size: 40
                  inv_default: 0
                }
                {
                  size: 8
                  inv_default: 105
                }
                {
                  size: 8
                  inv_default: 105
                }
                {
                  size: 8
                  inv_default: 105
                }
              ]
            }
            {
              size: 576
              items:
              [
                {
                  size: 64
                  inv_default: 17787990554517712170
                }
                {
                  size: 256
                  inv_default: 74703898927885615228644073031729127987260023218980427977577683364343954231749
                }
                {
                  size: 256
                  inv_default: 75416344968344595199184561357653563771667887286318218849004063607029244022168
                }
              ]
            }
            {
              size: 320
              items:
              [
                {
                  size: 64
                  inv_default: 17014664945089674915
                }
                {
                  size: 32
                  inv_default: 0
                }
                {
                  size: 32
                  inv_default: 0
                }
                {
                  size: 32
                  inv_default: 0
                }
                {
                  size: 32
                  inv_default: 0
                }
                {
                  size: 32
                  inv_default: 0
                }
                {
                  size: 32
                  inv_default: 0
                }
                {
                  size: 32
                  inv_default: 0
                }
                {
                  size: 32
                  inv_default: 0
                }
              ]
            }
            {
              size: 3776
              items:
              [
                {
                  size: 64
                  inv_default: 7388996329285901817
                }
                {
                  size: 256
                  inv_default: 0
                }
                {
                  size: 32
                  inv_default: 0
                }
                {
                  size: 256
                  inv_default: 0
                }
                {
                  size: 32
                  inv_default: 0
                }
                {
                  size: 32
                  inv_default: 0
                }
                {
                  size: 256
                  inv_default: 0
                }
                {
                  size: 32
                  inv_default: 0
                }
                {
                  size: 32
                  inv_default: 0
                }
                {
                  size: 256
                  inv_default: 0
                }
                {
                  size: 32
                  inv_default: 0
                }
                {
                  size: 32
                  inv_default: 0
                }
                {
                  size: 256
                  inv_default: 0
                }
                {
                  size: 32
                  inv_default: 0
                }
                {
                  size: 512
                  inv_default: 0
                }
                {
                  size: 32
                  inv_default: 0
                }
                {
                  size: 512
                  inv_default: 0
                }
                {
                  size: 32
                  inv_default: 0
                }
                {
                  size: 512
                  inv_default: 0
                }
                {
                  size: 32
                  inv_default: 0
                }
                {
                  size: 512
                  inv_default: 0
                }
                {
                  size: 32
                  inv_default: 0
                }
              ]
            }
            {
              size: 4864
              items:
              [
                {
                  size: 64
                  inv_default: 18239385572812637686
                }
                {
                  comment: unallocated space
                  size: 288
                  inv_default: 0
                }
                {
                  size: 32
                  inv_default: 0
                }
                {
                  size: 32
                  inv_default: 0
                }
                {
                  size: 32
                  inv_default: 0
                }
                {
                  size: 32
                  inv_default: 0
                }
                {
                  size: 32
                  inv_default: 0
                }
                {
                  size: 96
                  inv_default: 0
                }
                {
                  size: 32
                  inv_default: 0
                }
                {
                  size: 32
                  inv_default: 0
                }
                {
                  size: 32
                  inv_default: 0
                }
                {
                  size: 32
                  inv_default: 0
                }
                {
                  size: 32
                  inv_default: 0
                }
                {
                  size: 32
                  inv_default: 0
                }
                {
                  size: 32
                  inv_default: 0
                }
                {
                  size: 32
                  inv_default: 0
                }
                {
                  size: 32
                  inv_default: 0
                }
                {
                  size: 512
                  inv_default: 0
                }
                {
                  size: 128
                  inv_default: 0
                }
                {
                  size: 128
                  inv_default: 0
                }
                {
                  size: 512
                  inv_default: 0
                }
                {
                  size: 2560
                  inv_default: 0
                }
                {
                  size: 32
                  inv_default: 0
                }
                {
                  size: 32
                  inv_default: 0
                }
                {
                  size: 32
                  inv_default: 0
                }
                {
                  size: 32
                  inv_default: 0
                }
              ]
            }
            {
              size: 3136
              items:
              [
                {
                  size: 64
                  inv_default: 1763780682035308140
                }
                {
                  comment: unallocated space
                  size: 288
                  inv_default: 0
                }
                {
                  size: 256
                  inv_default: 0
                }
                {
                  size: 256
                  inv_default: 0
                }
                {
                  size: 32
                  inv_default: 0
                }
                {
                  size: 32
                  inv_default: 0
                }
                {
                  size: 32
                  inv_default: 0
                }
                {
                  size: 32
                  inv_default: 0
                }
                {
                  size: 32
                  inv_default: 0
                }
                {
                  size: 32
                  inv_default: 0
                }
                {
                  size: 32
                  inv_default: 0
                }
                {
                  size: 32
                  inv_default: 0
                }
                {
                  size: 32
                  inv_default: 0
                }
                {
                  size: 32
                  inv_default: 0
                }
                {
                  size: 32
                  inv_default: 0
                }
                {
                  size: 32
                  inv_default: 0
                }
                {
                  size: 32
                  inv_default: 0
                }
                {
                  size: 32
                  inv_default: 0
                }
                {
                  size: 32
                  inv_default: 0
                }
                {
                  size: 32
                  inv_default: 0
                }
                {
                  size: 32
                  inv_default: 0
                }
                {
                  size: 32
                  inv_default: 0
                }
                {
                  size: 32
                  inv_default: 0
                }
                {
                  size: 32
                  inv_default: 0
                }
                {
                  size: 32
                  inv_default: 0
                }
                {
                  size: 32
                  inv_default: 0
                }
                {
                  size: 32
                  inv_default: 0
                }
                {
                  size: 32
                  inv_default: 0
                }
                {
                  size: 32
                  inv_default: 0
                }
                {
                  size: 32
                  inv_default: 0
                }
                {
                  size: 32
                  inv_default: 0
                }
                {
                  size: 32
                  inv_default: 0
                }
                {
                  size: 32
                  inv_default: 0
                }
                {
                  size: 32
                  inv_default: 0
                }
                {
                  size: 32
                  inv_default: 0
                }
                {
                  size: 32
                  inv_default: 0
                }
                {
                  size: 1248
                  inv_default: 0
                }
              ]
            }
            {
              size: 512
              items:
              [
                {
                  size: 64
                  inv_default: 10376061010840826049
                }
                {
                  size: 448
                  inv_default: 0
                }
              ]
            }
          ]
          randwidth: 16384
        }
      ]
      template_type: otp_ctrl
      otp_mmap:
      {
        otp:
        {
          width: 2
          depth: 1024
          size: 2048
          addr_width: 10
          byte_addr_width: 11
        }
        scrambling:
        {
          key_size: 16
          iv_size: 8
          cnst_size: 16
          keys:
          [
            {
              name: Secret0Key
              value: 737351402483551773424408676158111452
            }
            {
              name: Secret1Key
              value: 159885627954823336570095967134108512624
            }
            {
              name: Secret2Key
              value: 116551551643964307065576810321281809078
            }
            {
              name: Secret3Key
              value: 205777243621407380322297933138314942540
            }
          ]
          digests:
          [
            {
              name: CnstyDigest
              iv_value: 11088963195337450739
              cnst_value: 155393554520195237829976329809831122921
            }
            {
              name: FlashDataKey
              iv_value: 9255441612745251312
              cnst_value: 162843381517727665979430423445830636732
            }
            {
              name: FlashAddrKey
              iv_value: 13554987153296870612
              cnst_value: 338159545346176504814408005524965135418
            }
            {
              name: SramDataKey
              iv_value: 4838032860035287177
              cnst_value: 299733559101879749609968710118787785495
            }
          ]
          num_keys: 4
          num_digests: 4
        }
        partitions:
        [
          {
            name: VENDOR_TEST
            variant: Unbuffered
            secret: false
            sw_digest: true
            hw_digest: false
            write_lock: Digest
            read_lock: CSR
            key_sel: NoKey
            integrity: false
            bkout_type: false
            skip_sw_header: true
            items:
            [
              {
                name: SCRATCH
                size: 56
                isdigest: false
                iszer: false
                ismubi: false
                iskeymgr_creator: false
                iskeymgr_owner: false
                absorb: false
                inv_default: 0
                offset: 0
              }
              {
                name: VENDOR_TEST_DIGEST
                size: 8
                offset: 56
                ismubi: false
                isdigest: true
                iszer: false
                inv_default: 10376061010840826049
                iskeymgr_creator: false
                iskeymgr_owner: false
              }
            ]
            desc:
              '''
              Vendor test partition.
              This is reserved for manufacturing smoke checks. The OTP wrapper
              control logic inside otp_macro is allowed to read/write to this
              region. ECC uncorrectable errors seen on the functional otp_macro
              interface will not lead to an alert for this partition.
              Instead, such errors will be reported as correctable ECC errors.
              '''
            absorb: false
            iskeymgr_creator: false
            iskeymgr_owner: false
            zeroizable: false
            ignore_read_lock_in_rma: false
            size: 64
            offset: 0
          }
          {
            name: CREATOR_SW_CFG
            variant: Unbuffered
            absorb: true
            secret: false
            sw_digest: true
            hw_digest: false
            write_lock: Digest
            read_lock: CSR
            key_sel: NoKey
            integrity: true
            bkout_type: false
            items:
            [
              {
                name: CREATOR_SW_CFG_AST_CFG
                size: 156
                desc:
                  '''
                  AST configuration data. These values get blindly copied to
                  the AST CSRs during ROM execution.
                  '''
                isdigest: false
                iszer: false
                ismubi: false
                iskeymgr_creator: false
                iskeymgr_owner: false
                absorb: false
                inv_default: 0
                offset: 64
              }
              {
                name: CREATOR_SW_CFG_AST_INIT_EN
                size: 4
                desc:
                  '''
                  Controls whether or not the CREATOR_SW_CFG_AST_CFG values
                  get copied to the AST CSRs during ROM execution.
                  A value of kMultiBitBool4True enables copying; all other
                  values disable.
                  '''
                isdigest: false
                iszer: false
                ismubi: false
                iskeymgr_creator: false
                iskeymgr_owner: false
                absorb: false
                inv_default: 0
                offset: 220
              }
              {
                name: CREATOR_SW_CFG_ROM_EXT_SKU
                size: 4
                desc: SKU identifier metadata. Unused by SiliconCreator software.
                isdigest: false
                iszer: false
                ismubi: false
                iskeymgr_creator: false
                iskeymgr_owner: false
                absorb: false
                inv_default: 0
                offset: 224
              }
              {
                name: CREATOR_SW_CFG_SIGVERIFY_SPX_EN
                size: 4
                desc:
                  '''
                  Controls whether or not SPHINCS+ signature verification will
                  be executed when the ROM attempts to boot the ROM_EXT.
                  A value of kSigverifySpxDisabledOtp disables SPHINCS+
                  signature verification, while all other values enable it.
                  Note, SPHINCS+ signature verification is always disabled in
                  TEST_UNLOCKED* LC states.
                  '''
                isdigest: false
                iszer: false
                ismubi: false
                iskeymgr_creator: false
                iskeymgr_owner: false
                absorb: false
                inv_default: 0
                offset: 228
              }
              {
                name: CREATOR_SW_CFG_FLASH_DATA_DEFAULT_CFG
                size: 4
                desc:
                  '''
                  The default scrambling, ECC, and high endurance
                  configuration settings for flash data pages set during ROM
                  execution.
                  '''
                isdigest: false
                iszer: false
                ismubi: false
                iskeymgr_creator: false
                iskeymgr_owner: false
                absorb: false
                inv_default: 0
                offset: 232
              }
              {
                name: CREATOR_SW_CFG_FLASH_INFO_BOOT_DATA_CFG
                size: 4
                desc:
                  '''
                  The scrambling, ECC, and high endurance configuration
                  settings for the boot data flash info pages set during ROM
                  execution.
                  '''
                isdigest: false
                iszer: false
                ismubi: false
                iskeymgr_creator: false
                iskeymgr_owner: false
                absorb: false
                inv_default: 0
                offset: 236
              }
              {
                name: CREATOR_SW_CFG_FLASH_HW_INFO_CFG_OVERRIDE
                size: 4
                desc:
                  '''
                  Scrambling and ECC configuration overrides (set by the ROM)
                  for the Creator and OwnerSeed flash info pages (pages 1 and
                  2 in partition 0) that are hardwired to the keygmr. By
                  default, scrambling and ECC on these flash info pages must
                  be enabled in order to successfully crank the keygmr (in the
                  ROM_EXT). However, values of kMultiBitBool4True for each
                  subfield in this field will disable this requirement. See
                  the HW_INFO_CFG_OVERRIDE flash_ctrl CSR for more details.
                  '''
                isdigest: false
                iszer: false
                ismubi: false
                iskeymgr_creator: false
                iskeymgr_owner: false
                absorb: false
                inv_default: 0
                offset: 240
              }
              {
                name: CREATOR_SW_CFG_RNG_EN
                size: 4
                desc:
                  '''
                  Whether or not to enable use of hardware generated entropy
                  (from the entropy complex via EDN) in the `rnd_uint32`
                  function. A value of kHardenedBoolTrue enables the use of
                  hardware generated entropy, while all other values disable.
                  '''
                isdigest: false
                iszer: false
                ismubi: false
                iskeymgr_creator: false
                iskeymgr_owner: false
                absorb: false
                inv_default: 0
                offset: 244
              }
              {
                name: CREATOR_SW_CFG_JITTER_EN
                size: 4
                desc:
                  '''
                  Whether or not to enable clock jitter. A value of
                  kMultiBitBool4False disables, while all other values enable.
                  '''
                isdigest: false
                iszer: false
                ismubi: false
                iskeymgr_creator: false
                iskeymgr_owner: false
                absorb: false
                inv_default: 0
                offset: 248
              }
              {
                name: CREATOR_SW_CFG_RET_RAM_RESET_MASK
                size: 4
                desc:
                  '''
                  Reset reason mask used to initialize (by overwriting with
                  random data) retention SRAM during ROM execution. A value of
                  0 only initializes retention SRAM on power-on-resets.See
                  rstmgr RESET_INFO CSR documentation for more details.
                  '''
                isdigest: false
                iszer: false
                ismubi: false
                iskeymgr_creator: false
                iskeymgr_owner: false
                absorb: false
                inv_default: 0
                offset: 252
              }
              {
                name: CREATOR_SW_CFG_MANUF_STATE
                size: 4
                desc:
                  '''
                  Manufacturing state binding field. For use by
                  SiliconCreators or SiliconOwners to bind ROM_EXT images to a
                  specific device or set of devices.
                  '''
                isdigest: false
                iszer: false
                ismubi: false
                iskeymgr_creator: false
                iskeymgr_owner: false
                absorb: false
                inv_default: 0
                offset: 256
              }
              {
                name: CREATOR_SW_CFG_ROM_EXEC_EN
                size: 4
                desc:
                  '''
                  Whether or not to enable execution of ROM. A value of 0
                  disables, while all other values enable. This enables
                  provisioning flows to attach JTAG connections and halt the
                  CPU before the device has been fully provisioned. All SKUs
                  should set this field to a non-zero value. Provisioning
                  flows shall take care to program this field at the
                  appropriate time during.
                  '''
                isdigest: false
                iszer: false
                ismubi: false
                iskeymgr_creator: false
                iskeymgr_owner: false
                absorb: false
                inv_default: 0
                offset: 260
              }
              {
                name: CREATOR_SW_CFG_CPUCTRL
                size: 4
                desc:
                  '''
                  Value to write to the Ibex CPUCTRL CSR during ROM execution.
                  This field controls settings such as ICACHE enablement. See
                  Ibex documentation for more information.
                  '''
                isdigest: false
                iszer: false
                ismubi: false
                iskeymgr_creator: false
                iskeymgr_owner: false
                absorb: false
                inv_default: 0
                offset: 264
              }
              {
                name: CREATOR_SW_CFG_MIN_SEC_VER_ROM_EXT
                size: 4
                desc:
                  '''
                  Value of the min_security_version_rom_ext field of the
                  default boot data.
                  '''
                isdigest: false
                iszer: false
                ismubi: false
                iskeymgr_creator: false
                iskeymgr_owner: false
                absorb: false
                inv_default: 0
                offset: 268
              }
              {
                name: CREATOR_SW_CFG_MIN_SEC_VER_BL0
                size: 4
                desc:
                  '''
                  Value of the min_security_version_bl0 field of the
                  default boot data.
                  '''
                isdigest: false
                iszer: false
                ismubi: false
                iskeymgr_creator: false
                iskeymgr_owner: false
                absorb: false
                inv_default: 0
                offset: 272
              }
              {
                name: CREATOR_SW_CFG_DEFAULT_BOOT_DATA_IN_PROD_EN
                size: 4
                desc:
                  '''
                  Whether or not to enable the default boot data in PROD and
                  PROD_END life cycle states. A value of kHardenedBoolTrue
                  enables, all other values disable. If left disabled,
                  provisioning flows are required to setup boot data pages
                  prior to enabling ROM execution. The default personalization
                  flow in `ft_personalize.c` configures these pages.
                  '''
                isdigest: false
                iszer: false
                ismubi: false
                iskeymgr_creator: false
                iskeymgr_owner: false
                absorb: false
                inv_default: 0
                offset: 276
              }
              {
                name: CREATOR_SW_CFG_RMA_SPIN_EN
                size: 4
                desc:
                  '''
                  Whether or not to enable a busy-wait delay loop in the ROM,
                  when a specific SW strapping configuration is applied during
                  boot, to provide time to trigger an RMA lifecycle transition
                  over JTAG. A value of kHardenedBoolTrue enables, all other
                  values disable.
                  '''
                isdigest: false
                iszer: false
                ismubi: false
                iskeymgr_creator: false
                iskeymgr_owner: false
                absorb: false
                inv_default: 0
                offset: 280
              }
              {
                name: CREATOR_SW_CFG_RMA_SPIN_CYCLES
                size: 4
                desc:
                  '''
                  The number of Ibex clock cycles to spin for when waiting for
                  an RMA transition. Used in combination with the
                  CREATOR_SW_CFG_RMA_SPIN_EN field.
                  '''
                isdigest: false
                iszer: false
                ismubi: false
                iskeymgr_creator: false
                iskeymgr_owner: false
                absorb: false
                inv_default: 0
                offset: 284
              }
              {
                name: CREATOR_SW_CFG_RNG_REPCNT_THRESHOLDS
                size: 4
                desc:
                  '''
                  The repetition count health test thresholds to enable
                  entropy_src with during ROM execution.
                  This must be configured if CREATOR_SW_CFG_RNG_EN is true.
                  See entropy_src documentation for more details.
                  '''
                isdigest: false
                iszer: false
                ismubi: false
                iskeymgr_creator: false
                iskeymgr_owner: false
                absorb: false
                inv_default: 0
                offset: 288
              }
              {
                name: CREATOR_SW_CFG_RNG_REPCNTS_THRESHOLDS
                size: 4
                desc:
                  '''
                  The repetition count symbol health test thresholds to enable
                  entropy_src with during ROM execution.
                  This must be configured if CREATOR_SW_CFG_RNG_EN is true.
                  See entropy_src documentation for more details.
                  '''
                isdigest: false
                iszer: false
                ismubi: false
                iskeymgr_creator: false
                iskeymgr_owner: false
                absorb: false
                inv_default: 0
                offset: 292
              }
              {
                name: CREATOR_SW_CFG_RNG_ADAPTP_HI_THRESHOLDS
                size: 4
                desc:
                  '''
                  The adaptive proportion health test high thresholds to
                  enable entropy_src with during ROM execution.
                  This must be configured if CREATOR_SW_CFG_RNG_EN is true.
                  See entropy_src documentation for more details.
                  '''
                isdigest: false
                iszer: false
                ismubi: false
                iskeymgr_creator: false
                iskeymgr_owner: false
                absorb: false
                inv_default: 0
                offset: 296
              }
              {
                name: CREATOR_SW_CFG_RNG_ADAPTP_LO_THRESHOLDS
                size: 4
                desc:
                  '''
                  The adaptive proportion health test low thresholds to enable
                  entropy_src with during ROM execution.
                  This must be configured if CREATOR_SW_CFG_RNG_EN is true.
                  See entropy_src documentation for more details.
                  '''
                isdigest: false
                iszer: false
                ismubi: false
                iskeymgr_creator: false
                iskeymgr_owner: false
                absorb: false
                inv_default: 0
                offset: 300
              }
              {
                name: CREATOR_SW_CFG_RNG_BUCKET_THRESHOLDS
                size: 4
                desc:
                  '''
                  The bucket health test thresholds to enable entropy_src with
                  during ROM execution.
                  This must be configured if CREATOR_SW_CFG_RNG_EN is true.
                  See entropy_src documentation for more details.
                  '''
                isdigest: false
                iszer: false
                ismubi: false
                iskeymgr_creator: false
                iskeymgr_owner: false
                absorb: false
                inv_default: 0
                offset: 304
              }
              {
                name: CREATOR_SW_CFG_RNG_MARKOV_HI_THRESHOLDS
                size: 4
                desc:
                  '''
                  The Markov health test high thresholds to enable entropy_src
                  with during ROM execution.
                  This must be configured if CREATOR_SW_CFG_RNG_EN is true.
                  See entropy_src documentation for more details.
                  '''
                isdigest: false
                iszer: false
                ismubi: false
                iskeymgr_creator: false
                iskeymgr_owner: false
                absorb: false
                inv_default: 0
                offset: 308
              }
              {
                name: CREATOR_SW_CFG_RNG_MARKOV_LO_THRESHOLDS
                size: 4
                desc:
                  '''
                  The Markov health test low thresholds to enable entropy_src
                  with during ROM execution.
                  This must be configured if CREATOR_SW_CFG_RNG_EN is true.
                  See entropy_src documentation for more details.
                  '''
                isdigest: false
                iszer: false
                ismubi: false
                iskeymgr_creator: false
                iskeymgr_owner: false
                absorb: false
                inv_default: 0
                offset: 312
              }
              {
                name: CREATOR_SW_CFG_RNG_EXTHT_HI_THRESHOLDS
                size: 4
                desc:
                  '''
                  The external health test high thresholds to enable the
                  entropy_src with during ROM execution.
                  This must be configured if CREATOR_SW_CFG_RNG_EN is true.
                  See entropy_src documentation for more details.
                  '''
                isdigest: false
                iszer: false
                ismubi: false
                iskeymgr_creator: false
                iskeymgr_owner: false
                absorb: false
                inv_default: 0
                offset: 316
              }
              {
                name: CREATOR_SW_CFG_RNG_EXTHT_LO_THRESHOLDS
                size: 4
                desc:
                  '''
                  The external health test low thresholds to enable the
                  entropy_src with during ROM execution.
                  This must be configured if CREATOR_SW_CFG_RNG_EN is true.
                  See entropy_src documentation for more details.
                  '''
                isdigest: false
                iszer: false
                ismubi: false
                iskeymgr_creator: false
                iskeymgr_owner: false
                absorb: false
                inv_default: 0
                offset: 320
              }
              {
                name: CREATOR_SW_CFG_RNG_ALERT_THRESHOLD
                size: 4
                desc:
                  '''
                  The alert threshold to configure the entropy_src with during
                  ROM execution.
                  This must be configured if CREATOR_SW_CFG_RNG_EN is true.
                  See entropy_src documentation for more details.
                  '''
                isdigest: false
                iszer: false
                ismubi: false
                iskeymgr_creator: false
                iskeymgr_owner: false
                absorb: false
                inv_default: 0
                offset: 324
              }
              {
                name: CREATOR_SW_CFG_RNG_HEALTH_CONFIG_DIGEST
                size: 4
                desc:
                  '''
                  A CRC32 digest of all entropy_src health test threshold
                  configuration fields above.
                  This must be configured if CREATOR_SW_CFG_RNG_EN is true.
                  See entropy_src documentation for more details.
                  '''
                isdigest: false
                iszer: false
                ismubi: false
                iskeymgr_creator: false
                iskeymgr_owner: false
                absorb: false
                inv_default: 0
                offset: 328
              }
              {
                name: CREATOR_SW_CFG_SRAM_KEY_RENEW_AND_INIT_EN
                size: 4
                desc:
                  '''
                  Whether or not the ROM should request SRAM to be rescrambled
                  with a new key on every boot. This includes renewing the
                  scrambling key and then initializing SRAM with pseudo-random
                  data. kHardenedBoolFalse disables, while all other values
                  enable.
                  '''
                isdigest: false
                iszer: false
                ismubi: false
                iskeymgr_creator: false
                iskeymgr_owner: false
                absorb: false
                inv_default: 0
                offset: 332
              }
              {
                name: CREATOR_SW_CFG_IMMUTABLE_ROM_EXT_EN
                size: 4
                desc:
                  '''
                  Enablement of the ROM_EXT immutable code section.
                  A value of kHardenedBoolTrue enables the feature.
                  All other values disable it.
                  '''
                isdigest: false
                iszer: false
                ismubi: false
                iskeymgr_creator: false
                iskeymgr_owner: false
                absorb: false
                inv_default: 0
                offset: 336
              }
              {
                name: CREATOR_SW_CFG_IMMUTABLE_ROM_EXT_START_OFFSET
                size: 4
                desc:
                  '''
                  Relative offset from the start of the ROM_EXT slot to
                  find the immutable code section at.
                  '''
                isdigest: false
                iszer: false
                ismubi: false
                iskeymgr_creator: false
                iskeymgr_owner: false
                absorb: false
                inv_default: 0
                offset: 340
              }
              {
                name: CREATOR_SW_CFG_IMMUTABLE_ROM_EXT_LENGTH
                size: 4
                desc: Length (in bytes) of the immutable code section.
                isdigest: false
                iszer: false
                ismubi: false
                iskeymgr_creator: false
                iskeymgr_owner: false
                absorb: false
                inv_default: 0
                offset: 344
              }
              {
                name: CREATOR_SW_CFG_IMMUTABLE_ROM_EXT_SHA256_HASH
                size: 32
                desc: SHA256 hash of the immutable ROM_EXT section.
                isdigest: false
                iszer: false
                ismubi: false
                iskeymgr_creator: false
                iskeymgr_owner: false
                absorb: false
                inv_default: 0
                offset: 348
              }
              {
                name: CREATOR_SW_CFG_RESERVED
                size: 32
                desc:
                  '''
                  Unused bits in the CREATOR_SW_CFG OTP partition. These can
                  be claimed by software as needed.
                  '''
                isdigest: false
                iszer: false
                ismubi: false
                iskeymgr_creator: false
                iskeymgr_owner: false
                absorb: false
                inv_default: 0
                offset: 380
              }
              {
                name: CREATOR_SW_CFG_DIGEST
                size: 8
                offset: 448
                ismubi: false
                isdigest: true
                iszer: false
                inv_default: 1763780682035308140
                iskeymgr_creator: false
                iskeymgr_owner: false
              }
            ]
            desc:
              '''
              Software configuration partition.
              This is for device-specific calibration data, e.g, clock, LDO, RNG,
              and configuration settings set by the ROM.
              '''
            iskeymgr_creator: false
            iskeymgr_owner: false
            zeroizable: false
            ignore_read_lock_in_rma: false
            size: 392
            offset: 64
          }
          {
            name: OWNER_SW_CFG
            variant: Unbuffered
            absorb: true
            secret: false
            sw_digest: true
            hw_digest: false
            write_lock: Digest
            read_lock: CSR
            key_sel: NoKey
            integrity: true
            bkout_type: false
            items:
            [
              {
                name: OWNER_SW_CFG_ROM_ERROR_REPORTING
                size: 4
                desc:
                  '''
                  The shutdown error reporting verbosity used by the ROM.
                  Should be configured to one of several
                  `shutdown_error_redact_t` values. See
                  `sw/device/silicon_creator/lib/shutdown.h` for more details.
                  '''
                isdigest: false
                iszer: false
                ismubi: false
                iskeymgr_creator: false
                iskeymgr_owner: false
                absorb: false
                inv_default: 0
                offset: 456
              }
              {
                name: OWNER_SW_CFG_ROM_BOOTSTRAP_DIS
                size: 4
                desc:
                  '''
                  Whether or not to disable ROM bootstrap mechanism. A value
                  of kHardenedBoolTrue disable bootstrap mechanism in the ROM,
                  while all other values enable it. Note, the provisioning
                  flow should take care when to program this field if it is
                  used by a SKU, as there is no way to get firmware into flash
                  in a PROD LC state if a valid ROM_EXT does not already exist
                  in flash once this value is configured to true.
                  '''
                isdigest: false
                iszer: false
                ismubi: false
                iskeymgr_creator: false
                iskeymgr_owner: false
                absorb: false
                inv_default: 0
                offset: 460
              }
              {
                name: OWNER_SW_CFG_ROM_ALERT_CLASS_EN
                size: 4
                desc:
                  '''
                  A four byte packed field, where each byte controls whether
                  or not the ROM enables each alert class (A through D) of the
                  alert_handler. The byte-sized subfields are arranged from D
                  to A, MSB to LSB. Each byte should be set to an
                  `alert_enable_t` value accordingly. See the alert_handler
                  documentation for more details.
                  '''
                isdigest: false
                iszer: false
                ismubi: false
                iskeymgr_creator: false
                iskeymgr_owner: false
                absorb: false
                inv_default: 0
                offset: 464
              }
              {
                name: OWNER_SW_CFG_ROM_ALERT_ESCALATION
                size: 4
                desc:
                  '''
                  A four byte packed field, where each byte controls the
                  escalation configuration for each alert class (A through D)
                  of the alert_handler configured by the ROM. The byte-sized
                  subfields are arranged from D to A, MSB to LSB. Each byte
                  should be set to an `alert_escalate_t` value accordingly.
                  See the alert_handler documentation for more details.
                  '''
                isdigest: false
                iszer: false
                ismubi: false
                iskeymgr_creator: false
                iskeymgr_owner: false
                absorb: false
                inv_default: 0
                offset: 468
              }
              {
                name: OWNER_SW_CFG_ROM_ALERT_CLASSIFICATION
                size: 320
                desc:
                  '''
                  The alert classifications (A through D) for each alert
                  source of the alert_handler to be configured by the ROM. The
                  field consists of a contiguous 320-byte block, or 80 32-bit
                  words. The four bytes in each word encode the configuration
                  of a single alert source across four lifecycle states, in
                  order from LSB to MSB: PROD, PROD_END, DEV, and RMA. Each
                  byte should be set to an `alert_class_t` value accordingly.
                  The order of the 80 32-bit words, from LSB to MSB can be
                  found in the EGRET_ALERTS list in `rules/const.bzl`.
                  See the alert_handler documentation for more details.
                  '''
                isdigest: false
                iszer: false
                ismubi: false
                iskeymgr_creator: false
                iskeymgr_owner: false
                absorb: false
                inv_default: 0
                offset: 472
              }
              {
                name: OWNER_SW_CFG_ROM_LOCAL_ALERT_CLASSIFICATION
                size: 64
                desc:
                  '''
                  Same as the `OWNER_SW_CFG_ROM_ALERT_CLASSIFICATION` field,
                  except these configuration correspond to the local alert
                  sources found in the `EGRET_LOC_ALERTS list in
                  `rules/const.bzl`.
                  '''
                isdigest: false
                iszer: false
                ismubi: false
                iskeymgr_creator: false
                iskeymgr_owner: false
                absorb: false
                inv_default: 0
                offset: 792
              }
              {
                name: OWNER_SW_CFG_ROM_ALERT_ACCUM_THRESH
                size: 16
                desc:
                  '''
                  The alert accumulation threshold values for each alert class
                  (A through D) of the alert_handler to be configured by the
                  ROM. This field consists of four 32-bit words encoding the
                  accumulation thresholds for each alert class A through D
                  arranged LSW to MSW. See the alert_handler documentation for
                  more details.
                  '''
                isdigest: false
                iszer: false
                ismubi: false
                iskeymgr_creator: false
                iskeymgr_owner: false
                absorb: false
                inv_default: 0
                offset: 856
              }
              {
                name: OWNER_SW_CFG_ROM_ALERT_TIMEOUT_CYCLES
                size: 16
                desc:
                  '''
                  Same as the `OWNER_SW_CFG_ROM_ALERT_ACCUM_THRESH` field,
                  except each value corresponds to the interrupt timeout
                  configuration of an alert class.
                  '''
                isdigest: false
                iszer: false
                ismubi: false
                iskeymgr_creator: false
                iskeymgr_owner: false
                absorb: false
                inv_default: 0
                offset: 872
              }
              {
                name: OWNER_SW_CFG_ROM_ALERT_PHASE_CYCLES
                size: 64
                desc:
                  '''
                  The alert escalation phase durations, measured in clock
                  cycles, the ROM will configure the four alert phases for
                  each alert class of the alert_handler. This field consists
                  of a contiguous 64-byte block, or an array of four 128-bit
                  fields. Each 128-bit subfield encodes four 32-bit words that
                  contain the alert phase cycle count configurations for alert
                  escalation phases 0 to 3, from LSW to MSW. Each 128-bit
                  subfield is contains all configurations for a single alert
                  class, arranged from class A to D, from LS to MS. For
                  example, the cycle durations of each escalation phase in
                  this field should be configured as such, from LSB to MSB:
                  <classA,phase0>...<classA,phase3>...<classD,phase0>...
                  <classD,phase3>. See the alert_handler documentation for
                  more details.
                  '''
                isdigest: false
                iszer: false
                ismubi: false
                iskeymgr_creator: false
                iskeymgr_owner: false
                absorb: false
                inv_default: 0
                offset: 888
              }
              {
                name: OWNER_SW_CFG_ROM_ALERT_DIGEST_PROD
                size: 4
                desc:
                  '''
                  The expected CRC32 digest over all of the alert_handler
                  configurations set up by the ROM for a device operating in
                  the PROD LC state. The ROM reads this field and checks it
                  against a digest it computes over the alert_handler
                  configuration it programmed. This field is expected to be
                  automatically computed by the `otp_alert_digest()` Bazel
                  rule. See the `alert_config_crc32()` function in the
                  SiliconCreator alert_handler driver for more details on what
                  configurations are included in this digest.
                  '''
                isdigest: false
                iszer: false
                ismubi: false
                iskeymgr_creator: false
                iskeymgr_owner: false
                absorb: false
                inv_default: 0
                offset: 952
              }
              {
                name: OWNER_SW_CFG_ROM_ALERT_DIGEST_PROD_END
                size: 4
                desc:
                  '''
                  Same as the `OWNER_SW_CFG_ROM_ALERT_DIGEST_PROD` field,
                  except the expected digest is for chips operating in the
                  PROD_END LC state.
                  '''
                isdigest: false
                iszer: false
                ismubi: false
                iskeymgr_creator: false
                iskeymgr_owner: false
                absorb: false
                inv_default: 0
                offset: 956
              }
              {
                name: OWNER_SW_CFG_ROM_ALERT_DIGEST_DEV
                size: 4
                desc:
                  '''
                  Same as the `OWNER_SW_CFG_ROM_ALERT_DIGEST_PROD` field,
                  except the expected digest is for chips operating in the
                  DEV LC state.
                  '''
                isdigest: false
                iszer: false
                ismubi: false
                iskeymgr_creator: false
                iskeymgr_owner: false
                absorb: false
                inv_default: 0
                offset: 960
              }
              {
                name: OWNER_SW_CFG_ROM_ALERT_DIGEST_RMA
                size: 4
                desc:
                  '''
                  Same as the `OWNER_SW_CFG_ROM_ALERT_DIGEST_PROD` field,
                  except the expected digest is for chips operating in the
                  RMA LC state.
                  '''
                isdigest: false
                iszer: false
                ismubi: false
                iskeymgr_creator: false
                iskeymgr_owner: false
                absorb: false
                inv_default: 0
                offset: 964
              }
              {
                name: OWNER_SW_CFG_ROM_WATCHDOG_BITE_THRESHOLD_CYCLES
                size: 4
                desc: Watchdog timer bite threshold (in cycles) configured by the ROM.
                isdigest: false
                iszer: false
                ismubi: false
                iskeymgr_creator: false
                iskeymgr_owner: false
                absorb: false
                inv_default: 0
                offset: 968
              }
              {
                name: OWNER_SW_CFG_ROM_KEYMGR_OTP_MEAS_EN
                size: 4
                desc:
                  '''
                  Whether or not to configure the attestation SW binding CSRs
                  of the keymgr with the value in ROM_EXT manifest or the
                  measurement of the OTP CreatorSwCfg, OwnerSwCfg, and
                  secure boot key integrity digest. A value of
                  kHardenedBoolTrue uses the ROM computed OTP measurements,
                  while all other values trigger the use of the binding values
                  included in the ROM_EXT manifest.
                  '''
                isdigest: false
                iszer: false
                ismubi: false
                iskeymgr_creator: false
                iskeymgr_owner: false
                absorb: false
                inv_default: 0
                offset: 972
              }
              {
                name: OWNER_SW_CFG_MANUF_STATE
                size: 4
                desc:
                  '''
                  Manufacturing state binding field. For use by
                  SiliconCreators or SiliconOwners to bind BL0 images to a
                  specific device or set of devices.
                  '''
                isdigest: false
                iszer: false
                ismubi: false
                iskeymgr_creator: false
                iskeymgr_owner: false
                absorb: false
                inv_default: 0
                offset: 976
              }
              {
                name: OWNER_SW_CFG_ROM_RSTMGR_INFO_EN
                size: 4
                desc:
                  '''
                  A two byte packed word that indicates the expected rstmgr
                  alert and CPU info dump enable states, configured in the
                  rstmgr's ALERT_INFO_CTRL and CPU_INFO_CTRL CSRs respectively.
                  The expected format of this fields is
                  {0,0,kHardenedBool*,kHardenedBool*}, read MSB to LSB, where
                  the left most kHardenedBool* entry indicates the expected
                  enablement state of the ALERT_INFO_CTRL, and the right most
                  indicates the enablement state of the CPU_INFO_CTRL. Since
                  the ROM expects both to be disabled upon handing over
                  execution control to the ROM_EXT, this entire OTP field
                  **should be left unprovisioned, or set to all 0**.
                  '''
                isdigest: false
                iszer: false
                ismubi: false
                iskeymgr_creator: false
                iskeymgr_owner: false
                absorb: false
                inv_default: 0
                offset: 980
              }
              {
                name: OWNER_SW_CFG_ROM_EXT_BOOTSTRAP_EN
                size: 4
                desc: Unused. Set to 0.
                isdigest: false
                iszer: false
                ismubi: false
                iskeymgr_creator: false
                iskeymgr_owner: false
                absorb: false
                inv_default: 0
                offset: 984
              }
              {
                name: OWNER_SW_CFG_ROM_SENSOR_CTRL_ALERT_CFG
                size: 12
                desc:
                  '''
                  Alert configuration values for the sensor_ctrl block
                  that will be configured by the ROM. This field is 12 bytes
                  long, where each byte contains two 4-bit packed subfields,
                  encoding two four bit boolean values (kMultiBitBool4False or
                  kMultiBitBool4True), as follows (read MSB to LSB):
                  {fatality, enablement}. For example, the byte 0x69 would
                  encode the alert is: 1) recoverable, and 2) disabled.

                  Currently, there are only 11 alerts in sensor_ctrl to
                  configure, thus only the least significant bytes in this
                  field are used.
                  '''
                isdigest: false
                iszer: false
                ismubi: false
                iskeymgr_creator: false
                iskeymgr_owner: false
                absorb: false
                inv_default: 0
                offset: 988
              }
              {
                name: OWNER_SW_CFG_ROM_SRAM_READBACK_EN
                size: 4
                desc:
                  '''
                  This field encodes the enablements of the readback security
                  features for the main and retention SRAMs to be configured
                  by the ROM. This field is four bytes, but the LSB contains
                  two 4-bit packed kMultiBitBool4* values that indicate the
                  enablement of the feature for the retention SRAM and
                  main SRAM, from MSB to LSB respectively. See the READBACK
                  CSR of the sram_ctrl for more details on this feature.
                  '''
                isdigest: false
                iszer: false
                ismubi: false
                iskeymgr_creator: false
                iskeymgr_owner: false
                absorb: false
                inv_default: 0
                offset: 1000
              }
              {
                name: OWNER_SW_CFG_ROM_PRESERVE_RESET_REASON_EN
                size: 4
                desc:
                  '''
                  Whether or not the ROM should preserve the reset reasons CSR
                  state in the rstmgr, or clear it. A value of
                  kHardenedBoolTrue preserves the CSR, while other values
                  trigger the ROM to clear the CSR after copying the reason to
                  the retention SRAM.
                  '''
                isdigest: false
                iszer: false
                ismubi: false
                iskeymgr_creator: false
                iskeymgr_owner: false
                absorb: false
                inv_default: 0
                offset: 1004
              }
              {
                name: OWNER_SW_CFG_ROM_RESET_REASON_CHECK_VALUE
                size: 4
                desc:
                  '''
                  Two packed 16-bit values that indicate whether the ROM
                  should perform a validation check on the the reset reasons
                  during boot. The validation check is a hardening mechanism
                  that checks the reset reasons for consistency at two
                  different points in time. Both packed values should be the
                  same. Values of kHardenedBoolFalse will instruct the ROM to
                  skip the reset reasons validation check, while all other
                  values will instruct the ROM to perform the check.
                  '''
                isdigest: false
                iszer: false
                ismubi: false
                iskeymgr_creator: false
                iskeymgr_owner: false
                absorb: false
                inv_default: 0
                offset: 1008
              }
              {
                name: OWNER_SW_CFG_ROM_BANNER_EN
                size: 4
                desc:
                  '''
                  Whether or not the ROM should print a banner message to the
                  console UART during boot. A value of kHardenedBoolFalse
                  disables the message printing, while all other values enable
                  it.
                  '''
                isdigest: false
                iszer: false
                ismubi: false
                iskeymgr_creator: false
                iskeymgr_owner: false
                absorb: false
                inv_default: 0
                offset: 1012
              }
              {
                name: OWNER_SW_CFG_ROM_FLASH_ECC_EXC_HANDLER_EN
                size: 4
                desc:
                  '''
                  Whether or not the ROM should use the flash ECC exception
                  handler during execution. A value of kHardenedBoolTrue
                  allows the ROM to use an the exception handler that recovers
                  gracefully and continues the boot process if a flash ECC
                  error is encountered during verification of a specific
                  ROM_EXT slot. This enables the ROM to attempt booting the
                  next ROM_EXT slot if the first slot attempted has been
                  corrupted. All other values trigger default ROM exception
                  handling, which is all exceptions trigger a chip shutdown
                  and reset.
                  '''
                isdigest: false
                iszer: false
                ismubi: false
                iskeymgr_creator: false
                iskeymgr_owner: false
                absorb: false
                inv_default: 0
                offset: 1016
              }
              {
                name: OWNER_SW_CFG_DIGEST
                size: 8
                offset: 1056
                ismubi: false
                isdigest: true
                iszer: false
                inv_default: 18239385572812637686
                iskeymgr_creator: false
                iskeymgr_owner: false
              }
            ]
            desc:
              '''
              Software configuration partition.
              This contains data that changes software behavior in the ROM, for
              example enabling defensive features in ROM or selecting failure
              modes if verification fails.
              '''
            iskeymgr_creator: false
            iskeymgr_owner: false
            zeroizable: false
            ignore_read_lock_in_rma: false
            size: 608
            offset: 456
          }
          {
            name: ROT_CREATOR_AUTH_CODESIGN
            variant: Unbuffered
            absorb: false
            secret: false
            sw_digest: true
            hw_digest: false
            write_lock: Digest
            read_lock: CSR
            key_sel: NoKey
            integrity: true
            bkout_type: false
            items:
            [
              {
                name: ROT_CREATOR_AUTH_CODESIGN_ECDSA_KEY_TYPE0
                size: 4
                isdigest: false
                iszer: false
                ismubi: false
                iskeymgr_creator: false
                iskeymgr_owner: false
                absorb: false
                inv_default: 0
                offset: 1064
              }
              {
                name: ROT_CREATOR_AUTH_CODESIGN_ECDSA_KEY0
                size: 64
                isdigest: false
                iszer: false
                ismubi: false
                iskeymgr_creator: false
                iskeymgr_owner: false
                absorb: false
                inv_default: 0
                offset: 1068
              }
              {
                name: ROT_CREATOR_AUTH_CODESIGN_ECDSA_KEY_TYPE1
                size: 4
                isdigest: false
                iszer: false
                ismubi: false
                iskeymgr_creator: false
                iskeymgr_owner: false
                absorb: false
                inv_default: 0
                offset: 1132
              }
              {
                name: ROT_CREATOR_AUTH_CODESIGN_ECDSA_KEY1
                size: 64
                isdigest: false
                iszer: false
                ismubi: false
                iskeymgr_creator: false
                iskeymgr_owner: false
                absorb: false
                inv_default: 0
                offset: 1136
              }
              {
                name: ROT_CREATOR_AUTH_CODESIGN_ECDSA_KEY_TYPE2
                size: 4
                isdigest: false
                iszer: false
                ismubi: false
                iskeymgr_creator: false
                iskeymgr_owner: false
                absorb: false
                inv_default: 0
                offset: 1200
              }
              {
                name: ROT_CREATOR_AUTH_CODESIGN_ECDSA_KEY2
                size: 64
                isdigest: false
                iszer: false
                ismubi: false
                iskeymgr_creator: false
                iskeymgr_owner: false
                absorb: false
                inv_default: 0
                offset: 1204
              }
              {
                name: ROT_CREATOR_AUTH_CODESIGN_ECDSA_KEY_TYPE3
                size: 4
                isdigest: false
                iszer: false
                ismubi: false
                iskeymgr_creator: false
                iskeymgr_owner: false
                absorb: false
                inv_default: 0
                offset: 1268
              }
              {
                name: ROT_CREATOR_AUTH_CODESIGN_ECDSA_KEY3
                size: 64
                isdigest: false
                iszer: false
                ismubi: false
                iskeymgr_creator: false
                iskeymgr_owner: false
                absorb: false
                inv_default: 0
                offset: 1272
              }
              {
                name: ROT_CREATOR_AUTH_CODESIGN_SPX_KEY_TYPE0
                size: 4
                isdigest: false
                iszer: false
                ismubi: false
                iskeymgr_creator: false
                iskeymgr_owner: false
                absorb: false
                inv_default: 0
                offset: 1336
              }
              {
                name: ROT_CREATOR_AUTH_CODESIGN_SPX_KEY0
                size: 32
                isdigest: false
                iszer: false
                ismubi: false
                iskeymgr_creator: false
                iskeymgr_owner: false
                absorb: false
                inv_default: 0
                offset: 1340
              }
              {
                name: ROT_CREATOR_AUTH_CODESIGN_SPX_KEY_CONFIG0
                size: 4
                isdigest: false
                iszer: false
                ismubi: false
                iskeymgr_creator: false
                iskeymgr_owner: false
                absorb: false
                inv_default: 0
                offset: 1372
              }
              {
                name: ROT_CREATOR_AUTH_CODESIGN_SPX_KEY_TYPE1
                size: 4
                isdigest: false
                iszer: false
                ismubi: false
                iskeymgr_creator: false
                iskeymgr_owner: false
                absorb: false
                inv_default: 0
                offset: 1376
              }
              {
                name: ROT_CREATOR_AUTH_CODESIGN_SPX_KEY1
                size: 32
                isdigest: false
                iszer: false
                ismubi: false
                iskeymgr_creator: false
                iskeymgr_owner: false
                absorb: false
                inv_default: 0
                offset: 1380
              }
              {
                name: ROT_CREATOR_AUTH_CODESIGN_SPX_KEY_CONFIG1
                size: 4
                isdigest: false
                iszer: false
                ismubi: false
                iskeymgr_creator: false
                iskeymgr_owner: false
                absorb: false
                inv_default: 0
                offset: 1412
              }
              {
                name: ROT_CREATOR_AUTH_CODESIGN_SPX_KEY_TYPE2
                size: 4
                isdigest: false
                iszer: false
                ismubi: false
                iskeymgr_creator: false
                iskeymgr_owner: false
                absorb: false
                inv_default: 0
                offset: 1416
              }
              {
                name: ROT_CREATOR_AUTH_CODESIGN_SPX_KEY2
                size: 32
                isdigest: false
                iszer: false
                ismubi: false
                iskeymgr_creator: false
                iskeymgr_owner: false
                absorb: false
                inv_default: 0
                offset: 1420
              }
              {
                name: ROT_CREATOR_AUTH_CODESIGN_SPX_KEY_CONFIG2
                size: 4
                isdigest: false
                iszer: false
                ismubi: false
                iskeymgr_creator: false
                iskeymgr_owner: false
                absorb: false
                inv_default: 0
                offset: 1452
              }
              {
                name: ROT_CREATOR_AUTH_CODESIGN_SPX_KEY_TYPE3
                size: 4
                isdigest: false
                iszer: false
                ismubi: false
                iskeymgr_creator: false
                iskeymgr_owner: false
                absorb: false
                inv_default: 0
                offset: 1456
              }
              {
                name: ROT_CREATOR_AUTH_CODESIGN_SPX_KEY3
                size: 32
                isdigest: false
                iszer: false
                ismubi: false
                iskeymgr_creator: false
                iskeymgr_owner: false
                absorb: false
                inv_default: 0
                offset: 1460
              }
              {
                name: ROT_CREATOR_AUTH_CODESIGN_SPX_KEY_CONFIG3
                size: 4
                isdigest: false
                iszer: false
                ismubi: false
                iskeymgr_creator: false
                iskeymgr_owner: false
                absorb: false
                inv_default: 0
                offset: 1492
              }
              {
                name: ROT_CREATOR_AUTH_CODESIGN_BLOCK_SHA2_256_HASH
                size: 32
                isdigest: false
                iszer: false
                ismubi: false
                iskeymgr_creator: false
                iskeymgr_owner: false
                absorb: false
                inv_default: 0
                offset: 1496
              }
              {
                name: ROT_CREATOR_AUTH_CODESIGN_DIGEST
                size: 8
                offset: 1528
                ismubi: false
                isdigest: true
                iszer: false
                inv_default: 7388996329285901817
                iskeymgr_creator: false
                iskeymgr_owner: false
              }
            ]
            desc:
              '''
              This OTP partition is used to store four P-256 keys
              and four Sphincs+ keys. The partition requires 464
              bytes of software visible storage. The partition is
              locked at manufacturing time to protect against
              malicious write attempts.
              '''
            iskeymgr_creator: false
            iskeymgr_owner: false
            zeroizable: false
            ignore_read_lock_in_rma: false
            size: 472
            offset: 1064
          }
          {
            name: ROT_CREATOR_AUTH_STATE
            variant: Unbuffered
            absorb: false
            secret: false
            sw_digest: true
            hw_digest: false
            write_lock: Digest
            read_lock: CSR
            key_sel: NoKey
            integrity: true
            bkout_type: false
            items:
            [
              {
                name: ROT_CREATOR_AUTH_STATE_ECDSA_KEY0
                size: 4
                isdigest: false
                iszer: false
                ismubi: false
                iskeymgr_creator: false
                iskeymgr_owner: false
                absorb: false
                inv_default: 0
                offset: 1536
              }
              {
                name: ROT_CREATOR_AUTH_STATE_ECDSA_KEY1
                size: 4
                isdigest: false
                iszer: false
                ismubi: false
                iskeymgr_creator: false
                iskeymgr_owner: false
                absorb: false
                inv_default: 0
                offset: 1540
              }
              {
                name: ROT_CREATOR_AUTH_STATE_ECDSA_KEY2
                size: 4
                isdigest: false
                iszer: false
                ismubi: false
                iskeymgr_creator: false
                iskeymgr_owner: false
                absorb: false
                inv_default: 0
                offset: 1544
              }
              {
                name: ROT_CREATOR_AUTH_STATE_ECDSA_KEY3
                size: 4
                isdigest: false
                iszer: false
                ismubi: false
                iskeymgr_creator: false
                iskeymgr_owner: false
                absorb: false
                inv_default: 0
                offset: 1548
              }
              {
                name: ROT_CREATOR_AUTH_STATE_SPX_KEY0
                size: 4
                isdigest: false
                iszer: false
                ismubi: false
                iskeymgr_creator: false
                iskeymgr_owner: false
                absorb: false
                inv_default: 0
                offset: 1552
              }
              {
                name: ROT_CREATOR_AUTH_STATE_SPX_KEY1
                size: 4
                isdigest: false
                iszer: false
                ismubi: false
                iskeymgr_creator: false
                iskeymgr_owner: false
                absorb: false
                inv_default: 0
                offset: 1556
              }
              {
                name: ROT_CREATOR_AUTH_STATE_SPX_KEY2
                size: 4
                isdigest: false
                iszer: false
                ismubi: false
                iskeymgr_creator: false
                iskeymgr_owner: false
                absorb: false
                inv_default: 0
                offset: 1560
              }
              {
                name: ROT_CREATOR_AUTH_STATE_SPX_KEY3
                size: 4
                isdigest: false
                iszer: false
                ismubi: false
                iskeymgr_creator: false
                iskeymgr_owner: false
                absorb: false
                inv_default: 0
                offset: 1564
              }
              {
                name: ROT_CREATOR_AUTH_STATE_DIGEST
                size: 8
                offset: 1568
                ismubi: false
                isdigest: true
                iszer: false
                inv_default: 17014664945089674915
                iskeymgr_creator: false
                iskeymgr_owner: false
              }
            ]
            desc:
              '''
              This OTP partition is used to capture the state of
              each key slot. Each key can be in one of the
              following states: BLANK, ENABLED, DISABLED. The
              encoded values are such that transitions between
              BLANK -> ENABLED ->  DISABLED are possible without
              causing ECC errors (this is a mechanism similar to
              how we manage life cycle state transitions). The
              partition is left unlocked to allow STATE updates in
              the field. The ROM_EXT is required to lock access to
              the OTP Direct Access Interface to prevent DoS
              attacks from malicious code executing on Silicon
              Owner partitions. DAI write locking is available in
              Egret.
              '''
            iskeymgr_creator: false
            iskeymgr_owner: false
            zeroizable: false
            ignore_read_lock_in_rma: false
            size: 40
            offset: 1536
          }
          {
            name: HW_CFG0
            variant: Buffered
            secret: false
            sw_digest: false
            hw_digest: true
            write_lock: Digest
            read_lock: None
            key_sel: NoKey
            integrity: true
            bkout_type: true
            skip_sw_header: true
            items:
            [
              {
                name: DEVICE_ID
                size: 32
                inv_default: 75416344968344595199184561357653563771667887286318218849004063607029244022168
                desc:
                  '''
                  Unique device identifier that is always exposed through the
                  lifecycle JTAG tap. See documentation on Device Identifiers.
                  '''
                isdigest: false
                iszer: false
                ismubi: false
                iskeymgr_creator: false
                iskeymgr_owner: false
                absorb: false
                offset: 1576
              }
              {
                name: MANUF_STATE
                size: 32
                inv_default: 74703898927885615228644073031729127987260023218980427977577683364343954231749
                desc:
                  '''
                  Field to capture manufacturing status. Currently unused. Set
                  to 0.
                  '''
                isdigest: false
                iszer: false
                ismubi: false
                iskeymgr_creator: false
                iskeymgr_owner: false
                absorb: false
                offset: 1608
              }
              {
                name: HW_CFG0_DIGEST
                size: 8
                offset: 1640
                ismubi: false
                isdigest: true
                iszer: false
                inv_default: 17787990554517712170
                iskeymgr_creator: false
                iskeymgr_owner: false
              }
            ]
            desc:
              '''
              Hardware configuration 0 partition.
              This contains a device identifier and manufacturing state.
              '''
            absorb: false
            iskeymgr_creator: false
            iskeymgr_owner: false
            zeroizable: false
            ignore_read_lock_in_rma: false
            size: 72
            offset: 1576
          }
          {
            name: HW_CFG1
            variant: Buffered
            secret: false
            sw_digest: false
            hw_digest: true
            write_lock: Digest
            read_lock: None
            key_sel: NoKey
            integrity: true
            bkout_type: true
            skip_sw_header: true
            items:
            [
              {
                name: EN_SRAM_IFETCH
                size: 1
                ismubi: true
                inv_default: 105
                desc:
                  '''
                  Enablement of execute from SRAM switch in the sram_ctrl (see
                  EXEC CSR). A kMultiBitBool8True value enables, while all
                  other values disable.
                  '''
                isdigest: false
                iszer: false
                iskeymgr_creator: false
                iskeymgr_owner: false
                absorb: false
                offset: 1648
              }
              {
                name: EN_CSRNG_SW_APP_READ
                size: 1
                ismubi: true
                inv_default: 105
                desc:
                  '''
                  Enablement of CSRNG software application interface. A
                  kMultiBitBool8True value enables, while all other values
                  disable. Enablement is required to extract output from
                  CSRNG via software.
                  '''
                isdigest: false
                iszer: false
                iskeymgr_creator: false
                iskeymgr_owner: false
                absorb: false
                offset: 1649
              }
              {
                name: DIS_RV_DM_LATE_DEBUG
                size: 1
                ismubi: true
                inv_default: 105
                desc:
                  '''
                  Disablement of RV_DM late debug feature (see rv_dm
                  documentation). A kMultiBitBool8True disables the late debug
                  feature and renders the rv_dm fully ungated in DEV lifecycle
                  states. All other values gate rv_dm reachability based on
                  the value of LATE_DEBUG_ENABLE CSR in the rv_dm block.
                  '''
                isdigest: false
                iszer: false
                iskeymgr_creator: false
                iskeymgr_owner: false
                absorb: false
                offset: 1650
              }
              {
                name: HW_CFG1_DIGEST
                size: 8
                offset: 1656
                ismubi: false
                isdigest: true
                iszer: false
                inv_default: 13248414165649443033
                iskeymgr_creator: false
                iskeymgr_owner: false
              }
            ]
            desc:
              '''
              Hardware configuration 1 partition.
              This contains several hardware feature switches.
              '''
            absorb: false
            iskeymgr_creator: false
            iskeymgr_owner: false
            zeroizable: false
            ignore_read_lock_in_rma: false
            size: 16
            offset: 1648
          }
          {
            name: SECRET0
            variant: Buffered
            secret: true
            sw_digest: false
            hw_digest: true
            write_lock: Digest
            read_lock: Digest
            ignore_read_lock_in_rma: true
            key_sel: Secret0Key
            integrity: true
            bkout_type: false
            skip_sw_header: true
            items:
            [
              {
                name: TEST_UNLOCK_TOKEN
                inv_default: 230748029623541578864187550162391519735
                size: 16
                isdigest: false
                iszer: false
                ismubi: false
                iskeymgr_creator: false
                iskeymgr_owner: false
                absorb: false
                offset: 1664
              }
              {
                name: TEST_EXIT_TOKEN
                inv_default: 335469059873213918850882942343750995942
                size: 16
                isdigest: false
                iszer: false
                ismubi: false
                iskeymgr_creator: false
                iskeymgr_owner: false
                absorb: false
                offset: 1680
              }
              {
                name: SECRET0_DIGEST
                size: 8
                offset: 1696
                ismubi: false
                isdigest: true
                iszer: false
                inv_default: 5835184937972759951
                iskeymgr_creator: false
                iskeymgr_owner: false
              }
            ]
            desc:
              '''
              Secret partition 0.
              This contains TEST lifecycle unlock tokens.
              '''
            absorb: false
            iskeymgr_creator: false
            iskeymgr_owner: false
            zeroizable: false
            size: 40
            offset: 1664
          }
          {
            name: SECRET1
            variant: Buffered
            secret: true
            sw_digest: false
            hw_digest: true
            write_lock: Digest
            read_lock: Digest
            ignore_read_lock_in_rma: true
            key_sel: Secret1Key
            integrity: true
            bkout_type: false
            skip_sw_header: true
            items:
            [
              {
                name: FLASH_ADDR_KEY_SEED
                inv_default: 23531955425096136348941735642650773479001928178605645757494297030518339325231
                size: 32
                isdigest: false
                iszer: false
                ismubi: false
                iskeymgr_creator: false
                iskeymgr_owner: false
                absorb: false
                offset: 1704
              }
              {
                name: FLASH_DATA_KEY_SEED
                inv_default: 7536910898370239450524093328085871963862640062161248607096610222518662706945
                size: 32
                isdigest: false
                iszer: false
                ismubi: false
                iskeymgr_creator: false
                iskeymgr_owner: false
                absorb: false
                offset: 1736
              }
              {
                name: SRAM_DATA_KEY_SEED
                inv_default: 334671433878751700697199779069205613746
                size: 16
                isdigest: false
                iszer: false
                ismubi: false
                iskeymgr_creator: false
                iskeymgr_owner: false
                absorb: false
                offset: 1768
              }
              {
                name: SECRET1_DIGEST
                size: 8
                offset: 1784
                ismubi: false
                isdigest: true
                iszer: false
                inv_default: 18410855119173665658
                iskeymgr_creator: false
                iskeymgr_owner: false
              }
            ]
            desc:
              '''
              Secret partition 1.
              This contains SRAM and flash scrambling keys.
              '''
            absorb: false
            iskeymgr_creator: false
            iskeymgr_owner: false
            zeroizable: false
            size: 88
            offset: 1704
          }
          {
            name: SECRET2
            variant: Buffered
            secret: true
            sw_digest: false
            hw_digest: true
            write_lock: Digest
            read_lock: Digest
            ignore_read_lock_in_rma: true
            key_sel: Secret2Key
            integrity: true
            bkout_type: false
            skip_sw_header: true
            items:
            [
              {
                name: RMA_TOKEN
                inv_default: 130971651290035026448304299560793978178
                size: 16
                isdigest: false
                iszer: false
                ismubi: false
                iskeymgr_creator: false
                iskeymgr_owner: false
                absorb: false
                offset: 1792
              }
              {
                name: CREATOR_ROOT_KEY_SHARE0
                inv_default: 92348881548169349828605117641018822276568973017337749653532230513078504803567
                size: 32
                iskeymgr_creator: true
                isdigest: false
                iszer: false
                ismubi: false
                iskeymgr_owner: false
                absorb: false
                offset: 1808
              }
              {
                name: CREATOR_ROOT_KEY_SHARE1
                inv_default: 33599205987092681210239649990958622833804933314610392317109421837165274603539
                size: 32
                iskeymgr_creator: true
                isdigest: false
                iszer: false
                ismubi: false
                iskeymgr_owner: false
                absorb: false
                offset: 1840
              }
              {
                name: CREATOR_SEED
                inv_default: 42840131334136411941200644947425579008419079534194068434596656023607238656790
                size: 32
                iskeymgr_creator: true
                isdigest: false
                iszer: false
                ismubi: false
                iskeymgr_owner: false
                absorb: false
                offset: 1872
              }
              {
                name: SECRET2_DIGEST
                size: 8
                offset: 1904
                ismubi: false
                isdigest: true
                iszer: false
                inv_default: 17765946314086229411
                iskeymgr_creator: false
                iskeymgr_owner: false
              }
            ]
            desc:
              '''
              Secret partition 2.
              This contains RMA unlock token, creator root key, and creator seed.
              '''
            absorb: false
            iskeymgr_creator: true
            iskeymgr_owner: false
            zeroizable: false
            size: 120
            offset: 1792
          }
          {
            name: SECRET3
            variant: Buffered
            secret: true
            sw_digest: false
            hw_digest: true
            write_lock: Digest
            read_lock: Digest
            key_sel: Secret3Key
            integrity: true
            bkout_type: false
            zeroizable: true
            skip_sw_header: true
            items:
            [
              {
                name: OWNER_SEED
                inv_default: 46917961507141145256060626454085849401363337700765221407992884200406625985337
                size: 32
                iskeymgr_owner: true
                isdigest: false
                iszer: false
                ismubi: false
                iskeymgr_creator: false
                absorb: false
                offset: 1912
              }
              {
                name: SECRET3_DIGEST
                size: 8
                offset: 1944
                ismubi: false
                isdigest: true
                iszer: false
                inv_default: 5776996463561863949
                iskeymgr_creator: false
                iskeymgr_owner: false
              }
              {
                name: SECRET3_ZER
                size: 8
                offset: 1952
                ismubi: false
                isdigest: false
                iszer: true
                inv_default: 0
                iskeymgr_creator: false
                iskeymgr_owner: false
              }
            ]
            desc:
              '''
              Secret partition 3.
              This contains the owner seed.
              '''
            absorb: false
            iskeymgr_creator: false
            iskeymgr_owner: true
            ignore_read_lock_in_rma: false
            size: 48
            offset: 1912
          }
          {
            name: LIFE_CYCLE
            variant: LifeCycle
            secret: false
            sw_digest: false
            hw_digest: false
            write_lock: None
            read_lock: None
            key_sel: NoKey
            integrity: true
            bkout_type: false
            skip_sw_header: true
            items:
            [
              {
                name: LC_TRANSITION_CNT
                inv_default: 6707296131048348035660209850454458516403716907741954216822891807334833183171263528798563328586680206667318424192181
                size: 48
                isdigest: false
                iszer: false
                ismubi: false
                iskeymgr_creator: false
                iskeymgr_owner: false
                absorb: false
                offset: 1960
              }
              {
                name: LC_STATE
                inv_default: 150724158863578290761376796642879324047970044817803993230695865344826642621771004974996689303386
                size: 40
                isdigest: false
                iszer: false
                ismubi: false
                iskeymgr_creator: false
                iskeymgr_owner: false
                absorb: false
                offset: 2008
              }
            ]
            desc:
              '''
              Lifecycle partition.
              This contains lifecycle transition count and state. This partition
              cannot be locked since the life cycle state needs to advance to RMA
              in-field. Note that while this partition is not marked secret, it
              is not readable nor writeable via the DAI. Only the LC controller
              can access this partition, and even via the LC controller it is not
              possible to read the raw manufacturing life cycle state in encoded
              form, since that encoding is considered a netlist secret. The LC
              controller only exposes a decoded version of this state.
              '''
            absorb: false
            iskeymgr_creator: false
            iskeymgr_owner: false
            zeroizable: false
            ignore_read_lock_in_rma: false
            size: 88
            offset: 1960
          }
        ]
      }
    }
    {
      name: lc_ctrl
      type: lc_ctrl
      base_addrs:
      {
        regs:
        {
          hart: 0x40140000
        }
        dmi:
        {
          hart: 0x0
        }
      }
      memory: {}
      param_list:
      [
        {
          name: RndCnstLcKeymgrDivInvalid
          desc: Diversification value used for all invalid life cycle states.
          type: lc_ctrl_pkg::lc_keymgr_div_t
          randcount: 128
          randtype: data
          name_top: RndCnstLcCtrlLcKeymgrDivInvalid
          default: 0x60da8b656eabb0b3ef6e9b197ce582fc
          randwidth: 128
        }
        {
          name: RndCnstLcKeymgrDivTestUnlocked
          desc: Diversification value used for the TEST_UNLOCKED* life cycle states.
          type: lc_ctrl_pkg::lc_keymgr_div_t
          randcount: 128
          randtype: data
          name_top: RndCnstLcCtrlLcKeymgrDivTestUnlocked
          default: 0x9b5965d697c23beafe8389e9f8ac17b7
          randwidth: 128
        }
        {
          name: RndCnstLcKeymgrDivDev
          desc: Diversification value used for the DEV life cycle state.
          type: lc_ctrl_pkg::lc_keymgr_div_t
          randcount: 128
          randtype: data
          name_top: RndCnstLcCtrlLcKeymgrDivDev
          default: 0xfebd3c5a12fd51bf1196b12e5259bded
          randwidth: 128
        }
        {
          name: RndCnstLcKeymgrDivProduction
          desc: Diversification value used for the PROD/PROD_END life cycle states.
          type: lc_ctrl_pkg::lc_keymgr_div_t
          randcount: 128
          randtype: data
          name_top: RndCnstLcCtrlLcKeymgrDivProduction
          default: 0x90261100c8ccc2b1be4599775614975d
          randwidth: 128
        }
        {
          name: RndCnstLcKeymgrDivRma
          desc: Diversification value used for the RMA life cycle state.
          type: lc_ctrl_pkg::lc_keymgr_div_t
          randcount: 128
          randtype: data
          name_top: RndCnstLcCtrlLcKeymgrDivRma
          default: 0x3d2b32e933d88e2e1cf65460f23fb780
          randwidth: 128
        }
        {
          name: RndCnstInvalidTokens
          desc: Compile-time random bits used for invalid tokens in the token mux
          type: lc_ctrl_pkg::lc_token_mux_t
          randcount: 1024
          randtype: data
          name_top: RndCnstLcCtrlInvalidTokens
          default: 0x499e6fcce64ceafd282c0e33fd2c07986c2a511755f072ee7a8e2fc45e111df07fa067f64056d9bf30d48543bec2e9a075d7d536d6f82505255ea0645554dd5f9355f5a89085a95a12ab13e0ec9ccd04512f5c01d8958ef421d22bb77013624b5a4bff0bdd4dd6b30b717aa80ff777a157878a468d23eecbd09de6b8f9faeaf1
          randwidth: 1024
        }
      ]
    }
    {
      name: alert_handler
      type: alert_handler
      base_addrs:
      {
        null:
        {
          hart: 0x40150000
        }
      }
      memory: {}
      param_list:
      [
        {
          name: RndCnstLfsrSeed
          desc: Compile-time random bits for initial LFSR seed
          type: alert_handler_pkg::lfsr_seed_t
          randcount: 32
          randtype: data
          name_top: RndCnstAlertHandlerLfsrSeed
          default: 0xa70e57e8
          randwidth: 32
        }
        {
          name: RndCnstLfsrPerm
          desc: Compile-time random permutation for LFSR output
          type: alert_handler_pkg::lfsr_perm_t
          randcount: 32
          randtype: perm
          name_top: RndCnstAlertHandlerLfsrPerm
          default: 0x92608b334d58703b80512e495dbe6ae79df31e9d
          randwidth: 160
        }
      ]
      template_type: alert_handler
    }
    {
      name: sram_ctrl_ret_aon
      type: sram_ctrl
      base_addrs:
      {
        regs:
        {
          hart: 0x40500000
        }
        ram:
        {
          hart: 0x40600000
        }
      }
      memory:
      {
        ram:
        {
          label: ram_ret_aon
          swaccess: rw
          data_intg_passthru: True
          exec: True
          byte_write: True
          size: 0x1000
        }
      }
      param_list:
      [
        {
          name: RndCnstSramKey
          desc: Compile-time random reset value for SRAM scrambling key.
          type: otp_ctrl_pkg::sram_key_t
          randcount: 128
          randtype: data
          name_top: RndCnstSramCtrlRetAonSramKey
          default: 0x382af33b479718558e6759764645aad1
          randwidth: 128
        }
        {
          name: RndCnstSramNonce
          desc: Compile-time random reset value for SRAM scrambling nonce.
          type: otp_ctrl_pkg::sram_nonce_t
          randcount: 128
          randtype: data
          name_top: RndCnstSramCtrlRetAonSramNonce
          default: 0xfb21c18124635e3d50a88f6808045627
          randwidth: 128
        }
        {
          name: RndCnstLfsrSeed
          desc: Compile-time random bits for initial LFSR seed
          type: sram_ctrl_pkg::lfsr_seed_t
          randcount: 64
          randtype: data
          name_top: RndCnstSramCtrlRetAonLfsrSeed
          default: 0xac18f377d9071bec
          randwidth: 64
        }
        {
          name: RndCnstLfsrPerm
          desc: Compile-time random permutation for LFSR output
          type: sram_ctrl_pkg::lfsr_perm_t
          randcount: 64
          randtype: perm
          name_top: RndCnstSramCtrlRetAonLfsrPerm
          default: 0x5535942e1e920f2c0e9f524fe066f1880728b26f9e21fce4a82074deb810bff61176e11968c1d71762a3b4de7dee5f29
          randwidth: 384
        }
      ]
    }
    {
      name: flash_ctrl
      type: flash_ctrl
      base_addrs:
      {
        core:
        {
          hart: 0x41000000
        }
        mem:
        {
          hart: 0x20000000
        }
      }
      memory:
      {
        mem:
        {
          label: eflash
          swaccess: ro
          data_intg_passthru: True
          exec: True
          byte_write: False
          config:
          {
            banks: 2
            data_width: 64
            info_types: 3
            infos_per_bank:
            [
              10
              1
              2
            ]
            pages_per_bank: 256
            program_resolution: 8
            size: 0x100000
            words_per_page: 256
          }
          size: 0x100000
        }
      }
      param_list:
      [
        {
          name: RndCnstAddrKey
          desc: Compile-time random bits for default address key
          type: flash_ctrl_pkg::flash_key_t
          randcount: 128
          randtype: data
          name_top: RndCnstFlashCtrlAddrKey
          default: 0xc70ea184c7a34193d59c735b5b4e2cbe
          randwidth: 128
        }
        {
          name: RndCnstDataKey
          desc: Compile-time random bits for default data key
          type: flash_ctrl_pkg::flash_key_t
          randcount: 128
          randtype: data
          name_top: RndCnstFlashCtrlDataKey
          default: 0xe5ab93cb024d6f8c0c700110cbf01425
          randwidth: 128
        }
        {
          name: RndCnstAllSeeds
          desc: Compile-time random bits for default seeds
          type: flash_ctrl_top_specific_pkg::all_seeds_t
          randcount: 512
          randtype: data
          name_top: RndCnstFlashCtrlAllSeeds
          default: 0xdaf5141df19a882a71d66b5953dbc603379da9efb2069bd79815b2f8d99a40e7fdc4fb13143d7753ce1cf9e2029207396945c95c9b54bae6aef30d8577834ccc
          randwidth: 512
        }
        {
          name: RndCnstLfsrSeed
          desc: Compile-time random bits for initial LFSR seed
          type: flash_ctrl_top_specific_pkg::lfsr_seed_t
          randcount: 32
          randtype: data
          name_top: RndCnstFlashCtrlLfsrSeed
          default: 0x6caaa63a
          randwidth: 32
        }
        {
          name: RndCnstLfsrPerm
          desc: Compile-time random permutation for LFSR output
          type: flash_ctrl_top_specific_pkg::lfsr_perm_t
          randcount: 32
          randtype: perm
          name_top: RndCnstFlashCtrlLfsrPerm
          default: 0x10d16acfc5cf08dfadeed4b7dc2427a5d5030191
          randwidth: 160
        }
      ]
      template_type: flash_ctrl
    }
    {
      name: acc
      type: acc
      base_addrs:
      {
        null:
        {
          hart: 0x41300000
        }
      }
      memory: {}
      param_list:
      [
        {
          name: RndCnstUrndPrngSeed
          desc: Default seed of the PRNG used for URND.
          type: acc_pkg::urnd_prng_seed_t
          randcount: 256
          randtype: data
          name_top: RndCnstAccUrndPrngSeed
          default: 0xe23a8cc31e2de5e578d43d2dce49e360cfb594acddf170684f6ead2b7febfe89
          randwidth: 256
        }
        {
          name: RndCnstAccKey
          desc: Compile-time random reset value for IMem/DMem scrambling key.
          type: otp_ctrl_pkg::acc_key_t
          randcount: 128
          randtype: data
          name_top: RndCnstAccAccKey
          default: 0x5523d7bc4846a485956c7f904b9eded0
          randwidth: 128
        }
        {
          name: RndCnstAccNonce
          desc: Compile-time random reset value for IMem/DMem scrambling nonce.
          type: otp_ctrl_pkg::acc_nonce_t
          randcount: 64
          randtype: data
          name_top: RndCnstAccAccNonce
          default: 0x9b89a75433566f49
          randwidth: 64
        }
      ]
    }
    {
      name: aes
      type: aes
      base_addrs:
      {
        null:
        {
          hart: 0x41100000
        }
      }
      memory: {}
      param_list:
      [
        {
          name: RndCnstClearingLfsrSeed
          desc: Default seed of the PRNG used for register clearing.
          type: aes_pkg::clearing_lfsr_seed_t
          randcount: 64
          randtype: data
          name_top: RndCnstAesClearingLfsrSeed
          default: 0x63d9dc27f3ecb11c
          randwidth: 64
        }
        {
          name: RndCnstClearingLfsrPerm
          desc: Permutation applied to the LFSR of the PRNG used for clearing.
          type: aes_pkg::clearing_lfsr_perm_t
          randcount: 64
          randtype: perm
          name_top: RndCnstAesClearingLfsrPerm
          default: 0xae32ad3072cd6496c80e64356bcfacc14d054d2001cf95e55a2627e84c5c768fdfa4f472576ecede0182921bfda9ebb8
          randwidth: 384
        }
        {
          name: RndCnstClearingSharePerm
          desc: Permutation applied to the clearing PRNG output for clearing the second share of registers.
          type: aes_pkg::clearing_lfsr_perm_t
          randcount: 64
          randtype: perm
          name_top: RndCnstAesClearingSharePerm
          default: 0x916527b07752950657eadfb9b98f0bca928de0888fffb4e0a1b7d103025c3b416bcc46aa3230959af8777b11bdd83d41
          randwidth: 384
        }
        {
          name: RndCnstMaskingLfsrSeed
          desc: Default seed of the PRNG used for masking.
          type: aes_pkg::masking_lfsr_seed_t
          randcount: 288
          randtype: data
          name_top: RndCnstAesMaskingLfsrSeed
          default: 0xf31a0165939d819d1518690e6473cdb2479391635057ca1045b9e1917e1ff0189b04a4f7
          randwidth: 288
        }
        {
          name: RndCnstMaskingLfsrPerm
          desc: Permutation applied to the output of the PRNG used for masking.
          type: aes_pkg::masking_lfsr_perm_t
          randcount: 160
          randtype: perm
          name_top: RndCnstAesMaskingLfsrPerm
          default: 0x97681c82188563539d6b8f6e2e9e87982657917a8c794a733f2586016575722345514d5d07463a0b83783b6c06373d749c38040c6d809070208839582d22992a485f5a3059499f032110291e1a35614e2781166740007d6a841232157611521d628d335e3c42242b7f505b93552c4c71132f9a1f920a34967b642831447e9402058b770f41476f3e5c43087c198914668e569b540d4b360e951b17694f8a0960
          randwidth: 1280
        }
      ]
    }
    {
      name: kmac
      type: kmac
      base_addrs:
      {
        null:
        {
          hart: 0x41120000
        }
      }
      memory: {}
      param_list:
      [
        {
          name: RndCnstLfsrSeed
          desc: Compile-time random data for PRNG default seed
          type: kmac_pkg::lfsr_seed_t
          randcount: 288
          randtype: data
          name_top: RndCnstKmacLfsrSeed
          default: 0x25910840042a75ecc25d4e2267e3bff26e003aacbf7d513aea01e9ee420d5b523f6b00c8
          randwidth: 288
        }
        {
          name: RndCnstLfsrPerm
          desc: Compile-time random permutation for PRNG output
          type: kmac_pkg::lfsr_perm_t
          randcount: 800
          randtype: perm
          name_top: RndCnstKmacLfsrPerm
          default: 0x48c6797a4d96d4061e345d6500f1de5deb818d18be0d329097b1464ab21106b02a692ba950044d32b595f9382856a4b9ddff9731cbe520adc8d6953c68da1229a03c9c1c40c5a72fb91d29429a812eb38349e92b051c51bb20e598e8aa62e5c52ef305cd0d111125b8675a68eabdbc4b90c6d35495cc2196ae84a4412c3cc998071a4e88ba141b98a1b01dbd97c56039655b14e8a1e683073bb0ef2dc6da5c657529b2cc8754e7fa89fe1566d1d1e33d5f8932332a61572d8c261eb5169085256b550d9a5c4a1c1d920374cd083b1eeac6521864244afc5f84c5ff0e45a1c52d6d60e221b19b3da519e0163a070a0a798e02d0c260ba5f27c5e5ada074987970db0b348c5a85d926cb65c2a166bf4097352832b45f3559f02ae806e646c2d8b9d6fa884681e80ca3631b814d349e9aee919f30f466d93355406496a90253eddb2ca03b3888b31e07bc1509e3720cac4569f7f142608ff1ba1a4162e2fec3341046f1a447299b9c333e54199ce447ee62c6866ec7f4e26e7b2d80bc7d6dcea7a0c8c1106ac2588b71d19851af92faad092fa0b9d2fe87e6a13c9d6d53d36a3d7d5ca74d350f59e31ad7050762bcbd71edd5bb0c4e50e09144282dc7597133eca238c76b2880b2264c446494f195d502e2b2986de01af4012272457d0795559efd9aea146a051a9d2bba3c56eff150d8288d97715767cf81398f70ad03def3634814889a4fa0a8c857c6d904b872a9e3516a00564dc200e28a8224a1933f82085a81102d229dbf325366be7b225742123f761645ed76610b528f094edeab505b04dce0fdd70ad892b96248595b00d46b841bd92a048d1375dd2489ca58a1c607e76845c5eb44c05fa567d35dc873e8f821e1112a858c11aaa9e9beae900ee5ea134de290f8cebb4ad41ce1c4f1147580965d9005e22988603418085e78aedf519721e21745c7c50c85a0cfd688cc17192809919ca4f022106ea4540d9866aa65f16b8c1ab6f8d5756c911cdfa75604d1b43d151b1ded878693b50ba24db1ddd0ab693309b6904b4b69c90d9dfc6654070023000057ae253d2d7160418178c34c3b3e0eaf0cb9a04d6b6c48da84896196067ec5a3b02701bd59c995a92ea098be39b6dfb0403a5bdd1c78c456307178e932969c7cd69b04814a6410968381b28914c430e37d949a383849df97180f26c5320a5d7d2e873161a8d4847a7a27c43b86186aaeb2a1142540a140e709b03bcac22daaf43d880ba3e51eb57f700c1a712ec358b06b492a0650aa8748f91294aa47502e2394e5ab06434fdb1ae5707020f69f0a9568ca48b03f2734055d00e061627625312664623c0fa9c2660ec932f28b0e58ec541f7dc29bdee47e98a616ea2962039ae361af05e5b308c1737a123ade41ec0559ac62406f
          randwidth: 8000
        }
        {
          name: RndCnstBufferLfsrSeed
          desc: Compile-time random data for PRNG buffer default seed
          type: kmac_pkg::buffer_lfsr_seed_t
          randcount: 800
          randtype: data
          name_top: RndCnstKmacBufferLfsrSeed
          default: 0xa9aaca4db84a32e5c6985a1a6435118b5f5f3fd3b9313116b67192d856dd742d40e072e417ad9a5f261204cbcc69a2147819b290a4bb0264347c0f91b0cec93c0129d85b95801dbe03f17e69dc260a79998eff5c710b67838adfb99a5eca671672cf19bc
          randwidth: 800
        }
        {
          name: RndCnstMsgPerm
          desc: Compile-time random permutation for LFSR Message output
          type: kmac_pkg::msg_perm_t
          randcount: 64
          randtype: perm
          name_top: RndCnstKmacMsgPerm
          default: 0xe4d3967ccc7d4325616a64ef7a88ae097ed1d4accb3d2040d1bdfe1a074723ca85d992788ec503964fd872712deb0ae9
          randwidth: 384
        }
      ]
    }
    {
      name: keymgr_dpe
      type: keymgr_dpe
      base_addrs:
      {
        null:
        {
          hart: 0x41140000
        }
      }
      memory: {}
      param_list:
      [
        {
          name: RndCnstLfsrSeed
          desc: Compile-time random bits for initial LFSR seed
          type: keymgr_pkg::lfsr_seed_t
          randcount: 64
          randtype: data
          name_top: RndCnstKeymgrDpeLfsrSeed
          default: 0x9a07effee457dee8
          randwidth: 64
        }
        {
          name: RndCnstLfsrPerm
          desc: Compile-time random permutation for LFSR output
          type: keymgr_pkg::lfsr_perm_t
          randcount: 64
          randtype: perm
          name_top: RndCnstKeymgrDpeLfsrPerm
          default: 0xabb890a369bd68b0ade4c2545dda528fac38c930187b3b075678347371aeae412f225f8dd61c5647c7c3385fcf6416ca
          randwidth: 384
        }
        {
          name: RndCnstRandPerm
          desc: Compile-time random permutation for entropy used in share overriding
          type: keymgr_pkg::rand_perm_t
          randcount: 32
          randtype: perm
          name_top: RndCnstKeymgrDpeRandPerm
          default: 0x4af980c948fd2ac33411742dd990fbc8c45f6aef
          randwidth: 160
        }
        {
          name: RndCnstRevisionSeed
          desc: Compile-time random bits for revision seed
          type: keymgr_pkg::seed_t
          randcount: 256
          randtype: data
          name_top: RndCnstKeymgrDpeRevisionSeed
          default: 0x8eee34d31387b45b91ce49e4e6b587941d1eec356888ae5343dd784cba5bebbe
          randwidth: 256
        }
        {
          name: RndCnstSoftOutputSeed
          desc: Compile-time random bits for software generation seed
          type: keymgr_pkg::seed_t
          randcount: 256
          randtype: data
          name_top: RndCnstKeymgrDpeSoftOutputSeed
          default: 0x2a6ead062d9516fdd8b110861a797cb684a3032ddac2da88d91cb1857dadcdfc
          randwidth: 256
        }
        {
          name: RndCnstHardOutputSeed
          desc: Compile-time random bits for hardware generation seed
          type: keymgr_pkg::seed_t
          randcount: 256
          randtype: data
          name_top: RndCnstKeymgrDpeHardOutputSeed
          default: 0x5c5f76d4a8e259d88dfe9b670aa0dd992bfe5d2e12489d22504aa7ac1c67f59c
          randwidth: 256
        }
        {
          name: RndCnstAesSeed
          desc: Compile-time random bits for generation seed when aes destination selected
          type: keymgr_pkg::seed_t
          randcount: 256
          randtype: data
          name_top: RndCnstKeymgrDpeAesSeed
          default: 0xba5482c1e35e6e3335c20cc778fc309917b9c870abe0895d76f862ef81f419e3
          randwidth: 256
        }
        {
          name: RndCnstKmacSeed
          desc: Compile-time random bits for generation seed when kmac destination selected
          type: keymgr_pkg::seed_t
          randcount: 256
          randtype: data
          name_top: RndCnstKeymgrDpeKmacSeed
          default: 0xc6cdc8662c71eac141666e443c6492d9bcf7a82420750e5dfc5e3ed4f2907532
          randwidth: 256
        }
        {
          name: RndCnstAccSeed
          desc: Compile-time random bits for generation seed when acc destination selected
          type: keymgr_pkg::seed_t
          randcount: 256
          randtype: data
          name_top: RndCnstKeymgrDpeAccSeed
          default: 0xe179ebec7ed7d3a5ef4982f73ed91c4b1cd0c85ec5e548b40184a69eb1e54396
          randwidth: 256
        }
        {
          name: RndCnstNoneSeed
          desc: Compile-time random bits for generation seed when no destination selected
          type: keymgr_pkg::seed_t
          randcount: 256
          randtype: data
          name_top: RndCnstKeymgrDpeNoneSeed
          default: 0x460e36c55c459efe9e43836fe878e464337ebcae3238dcdf7de88b56b405e02b
          randwidth: 256
        }
      ]
    }
    {
      name: csrng
      type: csrng
      base_addrs:
      {
        null:
        {
          hart: 0x41150000
        }
      }
      memory: {}
      param_list:
      [
        {
          name: RndCnstCsKeymgrDivNonProduction
          desc: Compile-time random bits for csrng state group diversification value
          type: csrng_pkg::cs_keymgr_div_t
          randcount: 384
          randtype: data
          name_top: RndCnstCsrngCsKeymgrDivNonProduction
          default: 0xbfd73849c511f7f0b79f91dcd1d589b4cac4372c385f89d902019dabb6dd57022c77ede8609c409d905b3c7819b26a67
          randwidth: 384
        }
        {
          name: RndCnstCsKeymgrDivProduction
          desc: Compile-time random bits for csrng state group diversification value
          type: csrng_pkg::cs_keymgr_div_t
          randcount: 384
          randtype: data
          name_top: RndCnstCsrngCsKeymgrDivProduction
          default: 0x4328819928c5d79bf1db63d11e1c31bbc9a8c73fc4cc3d14ca6bc0b96812de7c775a54ff19343cb32040b3490768889d
          randwidth: 384
        }
      ]
    }
    {
      name: sram_ctrl_main
      type: sram_ctrl
      base_addrs:
      {
        regs:
        {
          hart: 0x411C0000
        }
        ram:
        {
          hart: 0x10000000
        }
      }
      memory:
      {
        ram:
        {
          label: ram_main
          swaccess: rw
          data_intg_passthru: True
          exec: True
          byte_write: True
          size: 0x20000
        }
      }
      param_list:
      [
        {
          name: RndCnstSramKey
          desc: Compile-time random reset value for SRAM scrambling key.
          type: otp_ctrl_pkg::sram_key_t
          randcount: 128
          randtype: data
          name_top: RndCnstSramCtrlMainSramKey
          default: 0x27e0ba8588d34c05bcf127dae58b65d6
          randwidth: 128
        }
        {
          name: RndCnstSramNonce
          desc: Compile-time random reset value for SRAM scrambling nonce.
          type: otp_ctrl_pkg::sram_nonce_t
          randcount: 128
          randtype: data
          name_top: RndCnstSramCtrlMainSramNonce
          default: 0xa251088099b37107b1cccf1a955f03de
          randwidth: 128
        }
        {
          name: RndCnstLfsrSeed
          desc: Compile-time random bits for initial LFSR seed
          type: sram_ctrl_pkg::lfsr_seed_t
          randcount: 64
          randtype: data
          name_top: RndCnstSramCtrlMainLfsrSeed
          default: 0x1a8447bf83b69c50
          randwidth: 64
        }
        {
          name: RndCnstLfsrPerm
          desc: Compile-time random permutation for LFSR output
          type: sram_ctrl_pkg::lfsr_perm_t
          randcount: 64
          randtype: perm
          name_top: RndCnstSramCtrlMainLfsrPerm
          default: 0xa7d73a6a33fc6531eada6b8958012c60bfebbc534129de75461d084030b2b688a0946df07ce5576cc931ee7f9e5334b8
          randwidth: 384
        }
      ]
    }
    {
      name: rom_ctrl
      type: rom_ctrl
      base_addrs:
      {
        rom:
        {
          hart: 0x00008000
        }
        regs:
        {
          hart: 0x411e0000
        }
      }
      memory:
      {
        rom:
        {
          label: rom
          swaccess: ro
          data_intg_passthru: True
          exec: True
          byte_write: False
          size: 0x8000
        }
      }
      param_list:
      [
        {
          name: RndCnstScrNonce
          desc: Fixed nonce used for address / data scrambling
          type: bit [63:0]
          randcount: 64
          randtype: data
          name_top: RndCnstRomCtrlScrNonce
          default: 0x6f48d1401f8a6a52
          randwidth: 64
        }
        {
          name: RndCnstScrKey
          desc: Randomised constant used as a scrambling key for ROM data
          type: bit [127:0]
          randcount: 128
          randtype: data
          name_top: RndCnstRomCtrlScrKey
          default: 0x286f6954c27a9aefbe0bc9ee440c514c
          randwidth: 128
        }
      ]
    }
    {
      name: rv_core_ibex
      type: rv_core_ibex
      base_addrs:
      {
        cfg:
        {
          hart: 0x411F0000
        }
      }
      memory: {}
      param_list:
      [
        {
          name: RndCnstLfsrSeed
          desc: Default seed of the PRNG used for random instructions.
          type: ibex_pkg::lfsr_seed_t
          randcount: 32
          randtype: data
          name_top: RndCnstRvCoreIbexLfsrSeed
          default: 0xcacb0199
          randwidth: 32
        }
        {
          name: RndCnstLfsrPerm
          desc: Permutation applied to the LFSR of the PRNG used for random instructions.
          type: ibex_pkg::lfsr_perm_t
          randcount: 32
          randtype: perm
          name_top: RndCnstRvCoreIbexLfsrPerm
          default: 0x4d2cf092276f302d5d4873266283bbcfe0ba8fd2
          randwidth: 160
        }
        {
          name: RndCnstIbexKeyDefault
          desc: Default icache scrambling key
          type: logic [ibex_pkg::SCRAMBLE_KEY_W-1:0]
          randcount: 128
          randtype: data
          name_top: RndCnstRvCoreIbexIbexKeyDefault
          default: 0x23d8f96a41f062bb66b228701e8317c
          randwidth: 128
        }
        {
          name: RndCnstIbexNonceDefault
          desc: Default icache scrambling nonce
          type: logic [ibex_pkg::SCRAMBLE_NONCE_W-1:0]
          randcount: 64
          randtype: data
          name_top: RndCnstRvCoreIbexIbexNonceDefault
          default: 0xd4bf08bd6684a1d5
          randwidth: 64
        }
      ]
      template_type: rv_core_ibex
    }
  ]
}
