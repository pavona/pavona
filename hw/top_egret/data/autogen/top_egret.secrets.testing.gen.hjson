// Copyright lowRISC contributors (OpenTitan project).
// Licensed under the Apache License, Version 2.0, see LICENSE for details.
// SPDX-License-Identifier: Apache-2.0
//
// ------------------- W A R N I N G: A U T O - G E N E R A T E D   C O D E !! -------------------//
// PLEASE DO NOT HAND-EDIT THIS FILE. IT HAS BEEN AUTO-GENERATED WITH THE FOLLOWING COMMAND:
// util/topgen.py -t hw/top_egret/data/top_egret.hjson
//                -o hw/top_egret/
{
  seed:
  {
    topgen_seed:
    {
      seed_mode: testing
      value: 1017106219537032642877583828875051302543807092889754935647094601236425074047
    }
    otp_img_seed:
    {
      seed_mode: testing
      value: 52408960416235844780753299194502148156786072650816676092165912261205302331741
    }
    lc_ctrl_seed:
    {
      seed_mode: testing
      value: 40182201019264397688411770949626922549663256047001778394918990008320537410392
    }
  }
  module:
  [
    {
      name: otp_ctrl
      type: otp_ctrl
      base_addrs:
      {
        core:
        {
          hart: 0x40130000
        }
      }
      memory: {}
      param_list:
      [
        {
          name: RndCnstLfsrSeed
          desc: Compile-time random bits for initial LFSR seed
          type: otp_ctrl_top_specific_pkg::lfsr_seed_t
          randcount: 40
          randtype: data
          name_top: RndCnstOtpCtrlLfsrSeed
          default: 0xab13e0ec9c
          randwidth: 40
        }
        {
          name: RndCnstLfsrPerm
          desc: Compile-time random permutation for LFSR output
          type: otp_ctrl_top_specific_pkg::lfsr_perm_t
          randcount: 40
          randtype: perm
          name_top: RndCnstOtpCtrlLfsrPerm
          default: 0xd310d1a65471634a065e7d189085890f39a59b9dd94930270a2005cb501
          randwidth: 240
        }
        {
          name: RndCnstScrmblKeyInit
          desc: Compile-time random permutation for scrambling key/nonce register reset value
          type: otp_ctrl_top_specific_pkg::scrmbl_key_init_t
          randcount: 256
          randtype: data
          name_top: RndCnstOtpCtrlScrmblKeyInit
          default: 0xf833509acc7b3aa3fa7dac233e2b782306af306a1f36165ee14a00ee9ff9382a
          randwidth: 256
        }
        {
          name: RndCnstScrmblKey0
          desc: Compile-time scrambling key
          type: otp_ctrl_top_specific_pkg::key_t
          randcount: 128
          randtype: extdata
          name_top: RndCnstOtpCtrlScrmblKey0
          default: 0x8e023b1e052dac1e0fcebeac537edc
          randwidth: 128
        }
        {
          name: RndCnstScrmblKey1
          desc: Compile-time scrambling key
          type: otp_ctrl_top_specific_pkg::key_t
          randcount: 128
          randtype: extdata
          name_top: RndCnstOtpCtrlScrmblKey1
          default: 0x7848da13345040c295fcbd76684e7170
          randwidth: 128
        }
        {
          name: RndCnstScrmblKey2
          desc: Compile-time scrambling key
          type: otp_ctrl_top_specific_pkg::key_t
          randcount: 128
          randtype: extdata
          name_top: RndCnstOtpCtrlScrmblKey2
          default: 0x57af03288e6c3c383a73e698950bfab6
          randwidth: 128
        }
        {
          name: RndCnstScrmblKey3
          desc: Compile-time scrambling key
          type: otp_ctrl_top_specific_pkg::key_t
          randcount: 128
          randtype: extdata
          name_top: RndCnstOtpCtrlScrmblKey3
          default: 0x9acf416ad5455d1dea1ea059dc5c584c
          randwidth: 128
        }
        {
          name: RndCnstDigestConst0
          desc: Compile-time digest const
          type: otp_ctrl_top_specific_pkg::digest_const_t
          randcount: 128
          randtype: extdata
          name_top: RndCnstOtpCtrlDigestConst0
          default: 0x74e7b5c15957663ac0a5a56f968fd7e9
          randwidth: 128
        }
        {
          name: RndCnstDigestConst1
          desc: Compile-time digest const
          type: otp_ctrl_top_specific_pkg::digest_const_t
          randcount: 128
          randtype: extdata
          name_top: RndCnstOtpCtrlDigestConst1
          default: 0x7a827e95a7385b32c02abd645fc814bc
          randwidth: 128
        }
        {
          name: RndCnstDigestConst2
          desc: Compile-time digest const
          type: otp_ctrl_top_specific_pkg::digest_const_t
          randcount: 128
          randtype: extdata
          name_top: RndCnstOtpCtrlDigestConst2
          default: 0xfe6728d0d0879ec62214d76208e9943a
          randwidth: 128
        }
        {
          name: RndCnstDigestConst3
          desc: Compile-time digest const
          type: otp_ctrl_top_specific_pkg::digest_const_t
          randcount: 128
          randtype: extdata
          name_top: RndCnstOtpCtrlDigestConst3
          default: 0xe17e956c21b003d0bcb1cbcd1eb02317
          randwidth: 128
        }
        {
          name: RndCnstDigestIV0
          desc: Compile-time digest initial vector
          type: otp_ctrl_top_specific_pkg::digest_iv_t
          randcount: 64
          randtype: extdata
          name_top: RndCnstOtpCtrlDigestIV0
          default: 0x99e3e946397824f3
          randwidth: 64
        }
        {
          name: RndCnstDigestIV1
          desc: Compile-time digest initial vector
          type: otp_ctrl_top_specific_pkg::digest_iv_t
          randcount: 64
          randtype: extdata
          name_top: RndCnstOtpCtrlDigestIV1
          default: 0x8071ef1bff0c99f0
          randwidth: 64
        }
        {
          name: RndCnstDigestIV2
          desc: Compile-time digest initial vector
          type: otp_ctrl_top_specific_pkg::digest_iv_t
          randcount: 64
          randtype: extdata
          name_top: RndCnstOtpCtrlDigestIV2
          default: 0xbc1cfcff9f3e4cd4
          randwidth: 64
        }
        {
          name: RndCnstDigestIV3
          desc: Compile-time digest initial vector
          type: otp_ctrl_top_specific_pkg::digest_iv_t
          randcount: 64
          randtype: extdata
          name_top: RndCnstOtpCtrlDigestIV3
          default: 0x43242540d2120889
          randwidth: 64
        }
        {
          name: RndCnstPartInvDefault
          desc: OTP invalid partition default for buffered partitions
          type: logic [16383:0]
          randcount: 16384
          randtype: extdata
          name_top: RndCnstOtpCtrlPartInvDefault
          default:
          [
            {
              size: 704
              items:
              [
                {
                  size: 320
                  inv_default: 150724158863578290761376796642879324047970044817803993230695865344826642621771004974996689303386
                }
                {
                  size: 384
                  inv_default: 6707296131048348035660209850454458516403716907741954216822891807334833183171263528798563328586680206667318424192181
                }
              ]
            }
            {
              size: 384
              items:
              [
                {
                  size: 64
                  inv_default: 0
                }
                {
                  size: 64
                  inv_default: 354744590412343289
                }
                {
                  size: 256
                  inv_default: 46917961507141145256060626454085849401363337700765221407992884200406625985337
                }
              ]
            }
            {
              size: 960
              items:
              [
                {
                  size: 64
                  inv_default: 13961193720981549769
                }
                {
                  size: 256
                  inv_default: 42840131334136411941200644947425579008419079534194068434596656023607238656790
                }
                {
                  size: 256
                  inv_default: 33599205987092681210239649990958622833804933314610392317109421837165274603539
                }
                {
                  size: 256
                  inv_default: 92348881548169349828605117641018822276568973017337749653532230513078504803567
                }
                {
                  size: 128
                  inv_default: 130971651290035026448304299560793978178
                }
              ]
            }
            {
              size: 704
              items:
              [
                {
                  size: 64
                  inv_default: 12018756830038280371
                }
                {
                  size: 128
                  inv_default: 334671433878751700697199779069205613746
                }
                {
                  size: 256
                  inv_default: 7536910898370239450524093328085871963862640062161248607096610222518662706945
                }
                {
                  size: 256
                  inv_default: 23531955425096136348941735642650773479001928178605645757494297030518339325231
                }
              ]
            }
            {
              size: 320
              items:
              [
                {
                  size: 64
                  inv_default: 7532579203220097263
                }
                {
                  size: 128
                  inv_default: 335469059873213918850882942343750995942
                }
                {
                  size: 128
                  inv_default: 230748029623541578864187550162391519735
                }
              ]
            }
            {
              size: 384
              items:
              [
                {
                  size: 64
                  inv_default: 0
                }
                {
                  size: 64
                  inv_default: 6748737775371490481
                }
                {
                  size: 256
                  inv_default: 74703898927885615228644073031729127987260023218980427977577683364343954231749
                }
              ]
            }
            {
              size: 128
              items:
              [
                {
                  size: 64
                  inv_default: 16239032379200962209
                }
                {
                  comment: unallocated space
                  size: 40
                  inv_default: 0
                }
                {
                  size: 8
                  inv_default: 105
                }
                {
                  size: 8
                  inv_default: 105
                }
                {
                  size: 8
                  inv_default: 105
                }
              ]
            }
            {
              size: 320
              items:
              [
                {
                  size: 64
                  inv_default: 16772361003296535520
                }
                {
                  size: 256
                  inv_default: 75416344968344595199184561357653563771667887286318218849004063607029244022168
                }
              ]
            }
            {
              size: 192
              items:
              [
                {
                  size: 64
                  inv_default: 0
                }
                {
                  size: 128
                  inv_default: 0
                }
              ]
            }
            {
              size: 128
              items:
              [
                {
                  size: 64
                  inv_default: 5776996463561863949
                }
                {
                  size: 32
                  inv_default: 0
                }
                {
                  size: 32
                  inv_default: 0
                }
              ]
            }
            {
              size: 128
              items:
              [
                {
                  size: 64
                  inv_default: 17765946314086229411
                }
                {
                  size: 32
                  inv_default: 0
                }
                {
                  size: 32
                  inv_default: 0
                }
              ]
            }
            {
              size: 128
              items:
              [
                {
                  size: 64
                  inv_default: 18410855119173665658
                }
                {
                  size: 32
                  inv_default: 0
                }
                {
                  size: 32
                  inv_default: 0
                }
              ]
            }
            {
              size: 128
              items:
              [
                {
                  size: 64
                  inv_default: 5835184937972759951
                }
                {
                  size: 32
                  inv_default: 0
                }
                {
                  size: 32
                  inv_default: 0
                }
              ]
            }
            {
              size: 960
              items:
              [
                {
                  size: 64
                  inv_default: 0
                }
                {
                  size: 64
                  inv_default: 13248414165649443033
                }
                {
                  size: 32
                  inv_default: 0
                }
                {
                  size: 256
                  inv_default: 0
                }
                {
                  size: 512
                  inv_default: 0
                }
                {
                  size: 32
                  inv_default: 0
                }
              ]
            }
            {
              size: 960
              items:
              [
                {
                  size: 64
                  inv_default: 0
                }
                {
                  size: 64
                  inv_default: 17787990554517712170
                }
                {
                  size: 32
                  inv_default: 0
                }
                {
                  size: 256
                  inv_default: 0
                }
                {
                  size: 512
                  inv_default: 0
                }
                {
                  size: 32
                  inv_default: 0
                }
              ]
            }
            {
              size: 960
              items:
              [
                {
                  size: 64
                  inv_default: 0
                }
                {
                  size: 64
                  inv_default: 17014664945089674915
                }
                {
                  size: 32
                  inv_default: 0
                }
                {
                  size: 256
                  inv_default: 0
                }
                {
                  size: 512
                  inv_default: 0
                }
                {
                  size: 32
                  inv_default: 0
                }
              ]
            }
            {
              size: 960
              items:
              [
                {
                  size: 64
                  inv_default: 0
                }
                {
                  size: 64
                  inv_default: 7388996329285901817
                }
                {
                  size: 32
                  inv_default: 0
                }
                {
                  size: 256
                  inv_default: 0
                }
                {
                  size: 512
                  inv_default: 0
                }
                {
                  size: 32
                  inv_default: 0
                }
              ]
            }
            {
              size: 64
              items:
              [
                {
                  size: 64
                  inv_default: 0
                }
              ]
            }
            {
              size: 4672
              items:
              [
                {
                  size: 64
                  inv_default: 18239385572812637686
                }
                {
                  comment: unallocated space
                  size: 224
                  inv_default: 0
                }
                {
                  size: 32
                  inv_default: 0
                }
                {
                  size: 32
                  inv_default: 0
                }
                {
                  size: 96
                  inv_default: 0
                }
                {
                  size: 32
                  inv_default: 0
                }
                {
                  size: 32
                  inv_default: 0
                }
                {
                  size: 32
                  inv_default: 0
                }
                {
                  size: 32
                  inv_default: 0
                }
                {
                  size: 32
                  inv_default: 0
                }
                {
                  size: 32
                  inv_default: 0
                }
                {
                  size: 32
                  inv_default: 0
                }
                {
                  size: 32
                  inv_default: 0
                }
                {
                  size: 512
                  inv_default: 0
                }
                {
                  size: 128
                  inv_default: 0
                }
                {
                  size: 128
                  inv_default: 0
                }
                {
                  size: 512
                  inv_default: 0
                }
                {
                  size: 2560
                  inv_default: 0
                }
                {
                  size: 32
                  inv_default: 0
                }
                {
                  size: 32
                  inv_default: 0
                }
                {
                  size: 32
                  inv_default: 0
                }
                {
                  size: 32
                  inv_default: 0
                }
              ]
            }
            {
              size: 2688
              items:
              [
                {
                  size: 64
                  inv_default: 1763780682035308140
                }
                {
                  comment: unallocated space
                  size: 224
                  inv_default: 0
                }
                {
                  size: 256
                  inv_default: 0
                }
                {
                  size: 32
                  inv_default: 0
                }
                {
                  size: 32
                  inv_default: 0
                }
                {
                  size: 32
                  inv_default: 0
                }
                {
                  size: 32
                  inv_default: 0
                }
                {
                  size: 32
                  inv_default: 0
                }
                {
                  size: 32
                  inv_default: 0
                }
                {
                  size: 32
                  inv_default: 0
                }
                {
                  size: 32
                  inv_default: 0
                }
                {
                  size: 32
                  inv_default: 0
                }
                {
                  size: 32
                  inv_default: 0
                }
                {
                  size: 32
                  inv_default: 0
                }
                {
                  size: 32
                  inv_default: 0
                }
                {
                  size: 32
                  inv_default: 0
                }
                {
                  size: 32
                  inv_default: 0
                }
                {
                  size: 32
                  inv_default: 0
                }
                {
                  size: 32
                  inv_default: 0
                }
                {
                  size: 32
                  inv_default: 0
                }
                {
                  size: 32
                  inv_default: 0
                }
                {
                  size: 32
                  inv_default: 0
                }
                {
                  size: 32
                  inv_default: 0
                }
                {
                  size: 32
                  inv_default: 0
                }
                {
                  size: 32
                  inv_default: 0
                }
                {
                  size: 32
                  inv_default: 0
                }
                {
                  size: 32
                  inv_default: 0
                }
                {
                  size: 32
                  inv_default: 0
                }
                {
                  size: 32
                  inv_default: 0
                }
                {
                  size: 32
                  inv_default: 0
                }
                {
                  size: 32
                  inv_default: 0
                }
                {
                  size: 1248
                  inv_default: 0
                }
              ]
            }
            {
              size: 512
              items:
              [
                {
                  size: 64
                  inv_default: 10376061010840826049
                }
                {
                  size: 448
                  inv_default: 0
                }
              ]
            }
          ]
          randwidth: 16384
        }
      ]
      template_type: otp_ctrl
      otp_mmap:
      {
        otp:
        {
          width: 2
          depth: 1024
          size: 2048
          addr_width: 10
          byte_addr_width: 11
        }
        scrambling:
        {
          key_size: 16
          iv_size: 8
          cnst_size: 16
          keys:
          [
            {
              name: Secret0Key
              value: 737351402483551773424408676158111452
            }
            {
              name: Secret1Key
              value: 159885627954823336570095967134108512624
            }
            {
              name: Secret2Key
              value: 116551551643964307065576810321281809078
            }
            {
              name: Secret3Key
              value: 205777243621407380322297933138314942540
            }
          ]
          digests:
          [
            {
              name: CnstyDigest
              iv_value: 11088963195337450739
              cnst_value: 155393554520195237829976329809831122921
            }
            {
              name: FlashDataKey
              iv_value: 9255441612745251312
              cnst_value: 162843381517727665979430423445830636732
            }
            {
              name: FlashAddrKey
              iv_value: 13554987153296870612
              cnst_value: 338159545346176504814408005524965135418
            }
            {
              name: SramDataKey
              iv_value: 4838032860035287177
              cnst_value: 299733559101879749609968710118787785495
            }
          ]
          num_keys: 4
          num_digests: 4
        }
        partitions:
        [
          {
            name: VENDOR_TEST
            variant: Unbuffered
            secret: false
            sw_digest: true
            hw_digest: false
            write_lock: Digest
            read_lock: CSR
            key_sel: NoKey
            integrity: false
            bkout_type: false
            skip_sw_header: true
            items:
            [
              {
                name: SCRATCH
                size: 56
                isdigest: false
                iszer: false
                ismubi: false
                iskeymgr_creator: false
                iskeymgr_owner: false
                absorb: false
                inv_default: 0
                offset: 0
              }
              {
                name: VENDOR_TEST_DIGEST
                size: 8
                offset: 56
                ismubi: false
                isdigest: true
                iszer: false
                inv_default: 10376061010840826049
                iskeymgr_creator: false
                iskeymgr_owner: false
              }
            ]
            desc:
              '''
              Vendor test partition.
              This is reserved for manufacturing smoke checks. The OTP wrapper
              control logic inside otp_macro is allowed to read/write to this
              region. ECC uncorrectable errors seen on the functional otp_macro
              interface will not lead to an alert for this partition.
              Instead, such errors will be reported as correctable ECC errors.
              '''
            absorb: false
            iskeymgr_creator: false
            iskeymgr_owner: false
            zeroizable: false
            ignore_read_lock_in_rma: false
            size: 64
            offset: 0
          }
          {
            name: CREATOR_SW_CFG
            variant: Unbuffered
            absorb: true
            secret: false
            sw_digest: true
            hw_digest: false
            write_lock: Digest
            read_lock: CSR
            key_sel: NoKey
            integrity: true
            bkout_type: false
            items:
            [
              {
                name: CREATOR_SW_CFG_AST_CFG
                size: 156
                desc:
                  '''
                  AST configuration data. These values get blindly copied to
                  the AST CSRs during ROM execution.
                  '''
                isdigest: false
                iszer: false
                ismubi: false
                iskeymgr_creator: false
                iskeymgr_owner: false
                absorb: false
                inv_default: 0
                offset: 64
              }
              {
                name: CREATOR_SW_CFG_AST_INIT_SIZE
                size: 4
                desc:
                  '''
                  Controls how many 32-bit words from the CREATOR_SW_CFG_AST_CFG item
                  get copied to the AST CSRs during ROM execution.
                  '''
                isdigest: false
                iszer: false
                ismubi: false
                iskeymgr_creator: false
                iskeymgr_owner: false
                absorb: false
                inv_default: 0
                offset: 220
              }
              {
                name: CREATOR_SW_CFG_SIGVERIFY_SPX_EN
                size: 4
                desc:
                  '''
                  Controls whether or not SPHINCS+ signature verification will
                  be executed when the ROM attempts to boot the ROM_EXT.
                  A value of kSigverifySpxDisabledOtp disables SPHINCS+
                  signature verification, while all other values enable it.
                  '''
                isdigest: false
                iszer: false
                ismubi: false
                iskeymgr_creator: false
                iskeymgr_owner: false
                absorb: false
                inv_default: 0
                offset: 224
              }
              {
                name: CREATOR_SW_CFG_FLASH_DATA_DEFAULT_CFG
                size: 4
                desc:
                  '''
                  The default scrambling, ECC, and high endurance
                  configuration settings for flash data pages set during ROM
                  execution.
                  '''
                isdigest: false
                iszer: false
                ismubi: false
                iskeymgr_creator: false
                iskeymgr_owner: false
                absorb: false
                inv_default: 0
                offset: 228
              }
              {
                name: CREATOR_SW_CFG_FLASH_INFO_BOOT_DATA_CFG
                size: 4
                desc:
                  '''
                  The scrambling, ECC, and high endurance configuration
                  settings for the boot data flash info pages set during ROM
                  execution.
                  '''
                isdigest: false
                iszer: false
                ismubi: false
                iskeymgr_creator: false
                iskeymgr_owner: false
                absorb: false
                inv_default: 0
                offset: 232
              }
              {
                name: CREATOR_SW_CFG_FLASH_HW_INFO_CFG_OVERRIDE
                size: 4
                desc:
                  '''
                  Scrambling and ECC configuration overrides (set by the ROM)
                  for the Creator and OwnerSeed flash info pages (pages 1 and
                  2 in partition 0) that are hardwired to the keygmr. By
                  default, scrambling and ECC on these flash info pages must
                  be enabled in order to successfully crank the keygmr (in the
                  ROM_EXT). However, values of kMultiBitBool4True for each
                  subfield in this field will disable this requirement. See
                  the HW_INFO_CFG_OVERRIDE flash_ctrl CSR for more details.
                  '''
                isdigest: false
                iszer: false
                ismubi: false
                iskeymgr_creator: false
                iskeymgr_owner: false
                absorb: false
                inv_default: 0
                offset: 236
              }
              {
                name: CREATOR_SW_CFG_RNG_EN
                size: 4
                desc:
                  '''
                  Whether or not to enable use of hardware generated entropy
                  (from the entropy complex via EDN) in the `rnd_uint32`
                  function. A value of kHardenedBoolTrue enables the use of
                  hardware generated entropy, while all other values disable.
                  '''
                isdigest: false
                iszer: false
                ismubi: false
                iskeymgr_creator: false
                iskeymgr_owner: false
                absorb: false
                inv_default: 0
                offset: 240
              }
              {
                name: CREATOR_SW_CFG_JITTER_EN
                size: 4
                desc:
                  '''
                  Whether or not to enable clock jitter. A value of
                  kMultiBitBool4False disables, while all other values enable.
                  '''
                isdigest: false
                iszer: false
                ismubi: false
                iskeymgr_creator: false
                iskeymgr_owner: false
                absorb: false
                inv_default: 0
                offset: 244
              }
              {
                name: CREATOR_SW_CFG_RET_RAM_RESET_MASK
                size: 4
                desc:
                  '''
                  Reset reason mask used to initialize (by overwriting with
                  random data) retention SRAM during ROM execution. A value of
                  0 only initializes retention SRAM on power-on-resets.See
                  rstmgr RESET_INFO CSR documentation for more details.
                  '''
                isdigest: false
                iszer: false
                ismubi: false
                iskeymgr_creator: false
                iskeymgr_owner: false
                absorb: false
                inv_default: 0
                offset: 248
              }
              {
                name: CREATOR_SW_CFG_MANUF_STATE
                size: 4
                desc:
                  '''
                  Manufacturing state binding field. For use by
                  SiliconCreators or SiliconOwners to bind ROM_EXT images to a
                  specific device or set of devices.
                  '''
                isdigest: false
                iszer: false
                ismubi: false
                iskeymgr_creator: false
                iskeymgr_owner: false
                absorb: false
                inv_default: 0
                offset: 252
              }
              {
                name: CREATOR_SW_CFG_ROM_EXEC_EN
                size: 4
                desc:
                  '''
                  Whether or not to enable execution of ROM. A value of 0
                  disables, while all other values enable. This enables
                  provisioning flows to attach JTAG connections and halt the
                  CPU before the device has been fully provisioned. All SKUs
                  should set this field to a non-zero value. Provisioning
                  flows shall take care to program this field at the
                  appropriate time during.
                  '''
                isdigest: false
                iszer: false
                ismubi: false
                iskeymgr_creator: false
                iskeymgr_owner: false
                absorb: false
                inv_default: 0
                offset: 256
              }
              {
                name: CREATOR_SW_CFG_CPUCTRL
                size: 4
                desc:
                  '''
                  Value to write to the Ibex CPUCTRL CSR during ROM execution.
                  This field controls settings such as ICACHE enablement. See
                  Ibex documentation for more information.
                  '''
                isdigest: false
                iszer: false
                ismubi: false
                iskeymgr_creator: false
                iskeymgr_owner: false
                absorb: false
                inv_default: 0
                offset: 260
              }
              {
                name: CREATOR_SW_CFG_MIN_SEC_VER_ROM_EXT
                size: 4
                desc:
                  '''
                  Value of the min_security_version_rom_ext field of the
                  default boot data.
                  '''
                isdigest: false
                iszer: false
                ismubi: false
                iskeymgr_creator: false
                iskeymgr_owner: false
                absorb: false
                inv_default: 0
                offset: 264
              }
              {
                name: CREATOR_SW_CFG_MIN_SEC_VER_BL0
                size: 4
                desc:
                  '''
                  Value of the min_security_version_bl0 field of the
                  default boot data.
                  '''
                isdigest: false
                iszer: false
                ismubi: false
                iskeymgr_creator: false
                iskeymgr_owner: false
                absorb: false
                inv_default: 0
                offset: 268
              }
              {
                name: CREATOR_SW_CFG_RNG_REPCNT_THRESHOLDS
                size: 4
                desc:
                  '''
                  The repetition count health test thresholds to enable
                  entropy_src with during ROM execution.
                  This must be configured if CREATOR_SW_CFG_RNG_EN is true.
                  See entropy_src documentation for more details.
                  '''
                isdigest: false
                iszer: false
                ismubi: false
                iskeymgr_creator: false
                iskeymgr_owner: false
                absorb: false
                inv_default: 0
                offset: 272
              }
              {
                name: CREATOR_SW_CFG_RNG_REPCNTS_THRESHOLDS
                size: 4
                desc:
                  '''
                  The repetition count symbol health test thresholds to enable
                  entropy_src with during ROM execution.
                  This must be configured if CREATOR_SW_CFG_RNG_EN is true.
                  See entropy_src documentation for more details.
                  '''
                isdigest: false
                iszer: false
                ismubi: false
                iskeymgr_creator: false
                iskeymgr_owner: false
                absorb: false
                inv_default: 0
                offset: 276
              }
              {
                name: CREATOR_SW_CFG_RNG_ADAPTP_HI_THRESHOLDS
                size: 4
                desc:
                  '''
                  The adaptive proportion health test high thresholds to
                  enable entropy_src with during ROM execution.
                  This must be configured if CREATOR_SW_CFG_RNG_EN is true.
                  See entropy_src documentation for more details.
                  '''
                isdigest: false
                iszer: false
                ismubi: false
                iskeymgr_creator: false
                iskeymgr_owner: false
                absorb: false
                inv_default: 0
                offset: 280
              }
              {
                name: CREATOR_SW_CFG_RNG_ADAPTP_LO_THRESHOLDS
                size: 4
                desc:
                  '''
                  The adaptive proportion health test low thresholds to enable
                  entropy_src with during ROM execution.
                  This must be configured if CREATOR_SW_CFG_RNG_EN is true.
                  See entropy_src documentation for more details.
                  '''
                isdigest: false
                iszer: false
                ismubi: false
                iskeymgr_creator: false
                iskeymgr_owner: false
                absorb: false
                inv_default: 0
                offset: 284
              }
              {
                name: CREATOR_SW_CFG_RNG_BUCKET_THRESHOLDS
                size: 4
                desc:
                  '''
                  The bucket health test thresholds to enable entropy_src with
                  during ROM execution.
                  This must be configured if CREATOR_SW_CFG_RNG_EN is true.
                  See entropy_src documentation for more details.
                  '''
                isdigest: false
                iszer: false
                ismubi: false
                iskeymgr_creator: false
                iskeymgr_owner: false
                absorb: false
                inv_default: 0
                offset: 288
              }
              {
                name: CREATOR_SW_CFG_RNG_MARKOV_HI_THRESHOLDS
                size: 4
                desc:
                  '''
                  The Markov health test high thresholds to enable entropy_src
                  with during ROM execution.
                  This must be configured if CREATOR_SW_CFG_RNG_EN is true.
                  See entropy_src documentation for more details.
                  '''
                isdigest: false
                iszer: false
                ismubi: false
                iskeymgr_creator: false
                iskeymgr_owner: false
                absorb: false
                inv_default: 0
                offset: 292
              }
              {
                name: CREATOR_SW_CFG_RNG_MARKOV_LO_THRESHOLDS
                size: 4
                desc:
                  '''
                  The Markov health test low thresholds to enable entropy_src
                  with during ROM execution.
                  This must be configured if CREATOR_SW_CFG_RNG_EN is true.
                  See entropy_src documentation for more details.
                  '''
                isdigest: false
                iszer: false
                ismubi: false
                iskeymgr_creator: false
                iskeymgr_owner: false
                absorb: false
                inv_default: 0
                offset: 296
              }
              {
                name: CREATOR_SW_CFG_RNG_EXTHT_HI_THRESHOLDS
                size: 4
                desc:
                  '''
                  The external health test high thresholds to enable the
                  entropy_src with during ROM execution.
                  This must be configured if CREATOR_SW_CFG_RNG_EN is true.
                  See entropy_src documentation for more details.
                  '''
                isdigest: false
                iszer: false
                ismubi: false
                iskeymgr_creator: false
                iskeymgr_owner: false
                absorb: false
                inv_default: 0
                offset: 300
              }
              {
                name: CREATOR_SW_CFG_RNG_EXTHT_LO_THRESHOLDS
                size: 4
                desc:
                  '''
                  The external health test low thresholds to enable the
                  entropy_src with during ROM execution.
                  This must be configured if CREATOR_SW_CFG_RNG_EN is true.
                  See entropy_src documentation for more details.
                  '''
                isdigest: false
                iszer: false
                ismubi: false
                iskeymgr_creator: false
                iskeymgr_owner: false
                absorb: false
                inv_default: 0
                offset: 304
              }
              {
                name: CREATOR_SW_CFG_RNG_ALERT_THRESHOLD
                size: 4
                desc:
                  '''
                  The alert threshold to configure the entropy_src with during
                  ROM execution.
                  This must be configured if CREATOR_SW_CFG_RNG_EN is true.
                  See entropy_src documentation for more details.
                  '''
                isdigest: false
                iszer: false
                ismubi: false
                iskeymgr_creator: false
                iskeymgr_owner: false
                absorb: false
                inv_default: 0
                offset: 308
              }
              {
                name: CREATOR_SW_CFG_RNG_HEALTH_CONFIG_DIGEST
                size: 4
                desc:
                  '''
                  A CRC32 digest of all entropy_src health test threshold
                  configuration fields above.
                  This must be configured if CREATOR_SW_CFG_RNG_EN is true.
                  See entropy_src documentation for more details.
                  '''
                isdigest: false
                iszer: false
                ismubi: false
                iskeymgr_creator: false
                iskeymgr_owner: false
                absorb: false
                inv_default: 0
                offset: 312
              }
              {
                name: CREATOR_SW_CFG_SRAM_KEY_RENEW_AND_INIT_EN
                size: 4
                desc:
                  '''
                  Whether or not the ROM should request SRAM to be rescrambled
                  with a new key on every boot. This includes renewing the
                  scrambling key and then initializing SRAM with pseudo-random
                  data. kHardenedBoolFalse disables, while all other values
                  enable.
                  '''
                isdigest: false
                iszer: false
                ismubi: false
                iskeymgr_creator: false
                iskeymgr_owner: false
                absorb: false
                inv_default: 0
                offset: 316
              }
              {
                name: CREATOR_SW_CFG_IMMUTABLE_ROM_EXT_EN
                size: 4
                desc:
                  '''
                  Enablement of the ROM_EXT immutable code section.
                  A value of kHardenedBoolTrue enables the feature.
                  All other values disable it.
                  '''
                isdigest: false
                iszer: false
                ismubi: false
                iskeymgr_creator: false
                iskeymgr_owner: false
                absorb: false
                inv_default: 0
                offset: 320
              }
              {
                name: CREATOR_SW_CFG_IMMUTABLE_ROM_EXT_START_OFFSET
                size: 4
                desc:
                  '''
                  Relative offset from the start of the ROM_EXT slot to
                  find the immutable code section at.
                  '''
                isdigest: false
                iszer: false
                ismubi: false
                iskeymgr_creator: false
                iskeymgr_owner: false
                absorb: false
                inv_default: 0
                offset: 324
              }
              {
                name: CREATOR_SW_CFG_IMMUTABLE_ROM_EXT_LENGTH
                size: 4
                desc: Length (in bytes) of the immutable code section.
                isdigest: false
                iszer: false
                ismubi: false
                iskeymgr_creator: false
                iskeymgr_owner: false
                absorb: false
                inv_default: 0
                offset: 328
              }
              {
                name: CREATOR_SW_CFG_IMMUTABLE_ROM_EXT_SHA256_HASH
                size: 32
                desc: SHA256 hash of the immutable ROM_EXT section.
                isdigest: false
                iszer: false
                ismubi: false
                iskeymgr_creator: false
                iskeymgr_owner: false
                absorb: false
                inv_default: 0
                offset: 332
              }
              {
                name: CREATOR_SW_CFG_DIGEST
                size: 8
                offset: 392
                ismubi: false
                isdigest: true
                iszer: false
                inv_default: 1763780682035308140
                iskeymgr_creator: false
                iskeymgr_owner: false
              }
            ]
            desc:
              '''
              Software configuration partition.
              This is for device-specific calibration data, e.g, clock, LDO, RNG,
              and configuration settings set by the ROM.
              '''
            iskeymgr_creator: false
            iskeymgr_owner: false
            zeroizable: false
            ignore_read_lock_in_rma: false
            size: 336
            offset: 64
          }
          {
            name: OWNER_SW_CFG
            variant: Unbuffered
            absorb: true
            secret: false
            sw_digest: true
            hw_digest: false
            write_lock: Digest
            read_lock: CSR
            key_sel: NoKey
            integrity: true
            bkout_type: false
            items:
            [
              {
                name: OWNER_SW_CFG_ROM_ERROR_REPORTING
                size: 4
                desc:
                  '''
                  The shutdown error reporting verbosity used by the ROM.
                  Should be configured to one of several
                  `shutdown_error_redact_t` values. See
                  `sw/device/silicon_creator/lib/shutdown.h` for more details.
                  '''
                isdigest: false
                iszer: false
                ismubi: false
                iskeymgr_creator: false
                iskeymgr_owner: false
                absorb: false
                inv_default: 0
                offset: 400
              }
              {
                name: OWNER_SW_CFG_ROM_BOOTSTRAP_DIS
                size: 4
                desc:
                  '''
                  Whether or not to disable ROM bootstrap mechanism. A value
                  of kHardenedBoolTrue disable bootstrap mechanism in the ROM,
                  while all other values enable it. Note, the provisioning
                  flow should take care when to program this field if it is
                  used by a SKU, as there is no way to get firmware into flash
                  in a PROD LC state if a valid ROM_EXT does not already exist
                  in flash once this value is configured to true.
                  '''
                isdigest: false
                iszer: false
                ismubi: false
                iskeymgr_creator: false
                iskeymgr_owner: false
                absorb: false
                inv_default: 0
                offset: 404
              }
              {
                name: OWNER_SW_CFG_ROM_ALERT_CLASS_EN
                size: 4
                desc:
                  '''
                  A four byte packed field, where each byte controls whether
                  or not the ROM enables each alert class (A through D) of the
                  alert_handler. The byte-sized subfields are arranged from D
                  to A, MSB to LSB. Each byte should be set to an
                  `alert_enable_t` value accordingly. See the alert_handler
                  documentation for more details.
                  '''
                isdigest: false
                iszer: false
                ismubi: false
                iskeymgr_creator: false
                iskeymgr_owner: false
                absorb: false
                inv_default: 0
                offset: 408
              }
              {
                name: OWNER_SW_CFG_ROM_ALERT_ESCALATION
                size: 4
                desc:
                  '''
                  A four byte packed field, where each byte controls the
                  escalation configuration for each alert class (A through D)
                  of the alert_handler configured by the ROM. The byte-sized
                  subfields are arranged from D to A, MSB to LSB. Each byte
                  should be set to an `alert_escalate_t` value accordingly.
                  See the alert_handler documentation for more details.
                  '''
                isdigest: false
                iszer: false
                ismubi: false
                iskeymgr_creator: false
                iskeymgr_owner: false
                absorb: false
                inv_default: 0
                offset: 412
              }
              {
                name: OWNER_SW_CFG_ROM_ALERT_CLASSIFICATION
                size: 320
                desc:
                  '''
                  The alert classifications (A through D) for each alert
                  source of the alert_handler to be configured by the ROM. The
                  field consists of a contiguous 320-byte block, or 80 32-bit
                  words. The four bytes in each word encode the configuration
                  of a single alert source across four lifecycle states, in
                  order from LSB to MSB: PROD, PROD_END, DEV, and RMA. Each
                  byte should be set to an `alert_class_t` value accordingly.
                  The order of the 80 32-bit words, from LSB to MSB can be
                  found in the EGRET_ALERTS list in `rules/const.bzl`.
                  See the alert_handler documentation for more details.
                  '''
                isdigest: false
                iszer: false
                ismubi: false
                iskeymgr_creator: false
                iskeymgr_owner: false
                absorb: false
                inv_default: 0
                offset: 416
              }
              {
                name: OWNER_SW_CFG_ROM_LOCAL_ALERT_CLASSIFICATION
                size: 64
                desc:
                  '''
                  Same as the `OWNER_SW_CFG_ROM_ALERT_CLASSIFICATION` field,
                  except these configuration correspond to the local alert
                  sources found in the `EGRET_LOC_ALERTS list in
                  `rules/const.bzl`.
                  '''
                isdigest: false
                iszer: false
                ismubi: false
                iskeymgr_creator: false
                iskeymgr_owner: false
                absorb: false
                inv_default: 0
                offset: 736
              }
              {
                name: OWNER_SW_CFG_ROM_ALERT_ACCUM_THRESH
                size: 16
                desc:
                  '''
                  The alert accumulation threshold values for each alert class
                  (A through D) of the alert_handler to be configured by the
                  ROM. This field consists of four 32-bit words encoding the
                  accumulation thresholds for each alert class A through D
                  arranged LSW to MSW. See the alert_handler documentation for
                  more details.
                  '''
                isdigest: false
                iszer: false
                ismubi: false
                iskeymgr_creator: false
                iskeymgr_owner: false
                absorb: false
                inv_default: 0
                offset: 800
              }
              {
                name: OWNER_SW_CFG_ROM_ALERT_TIMEOUT_CYCLES
                size: 16
                desc:
                  '''
                  Same as the `OWNER_SW_CFG_ROM_ALERT_ACCUM_THRESH` field,
                  except each value corresponds to the interrupt timeout
                  configuration of an alert class.
                  '''
                isdigest: false
                iszer: false
                ismubi: false
                iskeymgr_creator: false
                iskeymgr_owner: false
                absorb: false
                inv_default: 0
                offset: 816
              }
              {
                name: OWNER_SW_CFG_ROM_ALERT_PHASE_CYCLES
                size: 64
                desc:
                  '''
                  The alert escalation phase durations, measured in clock
                  cycles, the ROM will configure the four alert phases for
                  each alert class of the alert_handler. This field consists
                  of a contiguous 64-byte block, or an array of four 128-bit
                  fields. Each 128-bit subfield encodes four 32-bit words that
                  contain the alert phase cycle count configurations for alert
                  escalation phases 0 to 3, from LSW to MSW. Each 128-bit
                  subfield is contains all configurations for a single alert
                  class, arranged from class A to D, from LS to MS. For
                  example, the cycle durations of each escalation phase in
                  this field should be configured as such, from LSB to MSB:
                  <classA,phase0>...<classA,phase3>...<classD,phase0>...
                  <classD,phase3>. See the alert_handler documentation for
                  more details.
                  '''
                isdigest: false
                iszer: false
                ismubi: false
                iskeymgr_creator: false
                iskeymgr_owner: false
                absorb: false
                inv_default: 0
                offset: 832
              }
              {
                name: OWNER_SW_CFG_ROM_ALERT_DIGEST_PROD
                size: 4
                desc:
                  '''
                  The expected CRC32 digest over all of the alert_handler
                  configurations set up by the ROM for a device operating in
                  the PROD LC state. The ROM reads this field and checks it
                  against a digest it computes over the alert_handler
                  configuration it programmed. This field is expected to be
                  automatically computed by the `otp_alert_digest()` Bazel
                  rule. See the `alert_config_crc32()` function in the
                  SiliconCreator alert_handler driver for more details on what
                  configurations are included in this digest.
                  '''
                isdigest: false
                iszer: false
                ismubi: false
                iskeymgr_creator: false
                iskeymgr_owner: false
                absorb: false
                inv_default: 0
                offset: 896
              }
              {
                name: OWNER_SW_CFG_ROM_ALERT_DIGEST_PROD_END
                size: 4
                desc:
                  '''
                  Same as the `OWNER_SW_CFG_ROM_ALERT_DIGEST_PROD` field,
                  except the expected digest is for chips operating in the
                  PROD_END LC state.
                  '''
                isdigest: false
                iszer: false
                ismubi: false
                iskeymgr_creator: false
                iskeymgr_owner: false
                absorb: false
                inv_default: 0
                offset: 900
              }
              {
                name: OWNER_SW_CFG_ROM_ALERT_DIGEST_DEV
                size: 4
                desc:
                  '''
                  Same as the `OWNER_SW_CFG_ROM_ALERT_DIGEST_PROD` field,
                  except the expected digest is for chips operating in the
                  DEV LC state.
                  '''
                isdigest: false
                iszer: false
                ismubi: false
                iskeymgr_creator: false
                iskeymgr_owner: false
                absorb: false
                inv_default: 0
                offset: 904
              }
              {
                name: OWNER_SW_CFG_ROM_ALERT_DIGEST_RMA
                size: 4
                desc:
                  '''
                  Same as the `OWNER_SW_CFG_ROM_ALERT_DIGEST_PROD` field,
                  except the expected digest is for chips operating in the
                  RMA LC state.
                  '''
                isdigest: false
                iszer: false
                ismubi: false
                iskeymgr_creator: false
                iskeymgr_owner: false
                absorb: false
                inv_default: 0
                offset: 908
              }
              {
                name: OWNER_SW_CFG_ROM_WATCHDOG_BITE_THRESHOLD_CYCLES
                size: 4
                desc: Watchdog timer bite threshold (in cycles) configured by the ROM.
                isdigest: false
                iszer: false
                ismubi: false
                iskeymgr_creator: false
                iskeymgr_owner: false
                absorb: false
                inv_default: 0
                offset: 912
              }
              {
                name: OWNER_SW_CFG_ROM_KEYMGR_OTP_MEAS_EN
                size: 4
                desc:
                  '''
                  Whether or not to configure the attestation SW binding CSRs
                  of the keymgr with the value in ROM_EXT manifest or the
                  measurement of the OTP CreatorSwCfg, OwnerSwCfg, and
                  secure boot key integrity digest. A value of
                  kHardenedBoolTrue uses the ROM computed OTP measurements,
                  while all other values trigger the use of the binding values
                  included in the ROM_EXT manifest.
                  '''
                isdigest: false
                iszer: false
                ismubi: false
                iskeymgr_creator: false
                iskeymgr_owner: false
                absorb: false
                inv_default: 0
                offset: 916
              }
              {
                name: OWNER_SW_CFG_MANUF_STATE
                size: 4
                desc:
                  '''
                  Manufacturing state binding field. For use by
                  SiliconCreators or SiliconOwners to bind BL0 images to a
                  specific device or set of devices.
                  '''
                isdigest: false
                iszer: false
                ismubi: false
                iskeymgr_creator: false
                iskeymgr_owner: false
                absorb: false
                inv_default: 0
                offset: 920
              }
              {
                name: OWNER_SW_CFG_ROM_RSTMGR_INFO_EN
                size: 4
                desc:
                  '''
                  A two byte packed word that indicates the expected rstmgr
                  alert and CPU info dump enable states, configured in the
                  rstmgr's ALERT_INFO_CTRL and CPU_INFO_CTRL CSRs respectively.
                  The expected format of this fields is
                  {0,0,kHardenedBool*,kHardenedBool*}, read MSB to LSB, where
                  the left most kHardenedBool* entry indicates the expected
                  enablement state of the ALERT_INFO_CTRL, and the right most
                  indicates the enablement state of the CPU_INFO_CTRL. Since
                  the ROM expects both to be disabled upon handing over
                  execution control to the ROM_EXT, this entire OTP field
                  **should be left unprovisioned, or set to all 0**.
                  '''
                isdigest: false
                iszer: false
                ismubi: false
                iskeymgr_creator: false
                iskeymgr_owner: false
                absorb: false
                inv_default: 0
                offset: 924
              }
              {
                name: OWNER_SW_CFG_ROM_SENSOR_CTRL_ALERT_CFG
                size: 12
                desc:
                  '''
                  Alert configuration values for the sensor_ctrl block
                  that will be configured by the ROM. This field is 12 bytes
                  long, where each byte contains two 4-bit packed subfields,
                  encoding two four bit boolean values (kMultiBitBool4False or
                  kMultiBitBool4True), as follows (read MSB to LSB):
                  {fatality, enablement}. For example, the byte 0x69 would
                  encode the alert is: 1) recoverable, and 2) disabled.

                  Currently, there are only 11 alerts in sensor_ctrl to
                  configure, thus only the least significant bytes in this
                  field are used.
                  '''
                isdigest: false
                iszer: false
                ismubi: false
                iskeymgr_creator: false
                iskeymgr_owner: false
                absorb: false
                inv_default: 0
                offset: 928
              }
              {
                name: OWNER_SW_CFG_ROM_SRAM_READBACK_EN
                size: 4
                desc:
                  '''
                  This field encodes the enablements of the readback security
                  features for the main and retention SRAMs to be configured
                  by the ROM. This field is four bytes, but the LSB contains
                  two 4-bit packed kMultiBitBool4* values that indicate the
                  enablement of the feature for the retention SRAM and
                  main SRAM, from MSB to LSB respectively. See the READBACK
                  CSR of the sram_ctrl for more details on this feature.
                  '''
                isdigest: false
                iszer: false
                ismubi: false
                iskeymgr_creator: false
                iskeymgr_owner: false
                absorb: false
                inv_default: 0
                offset: 940
              }
              {
                name: OWNER_SW_CFG_ROM_FLASH_ECC_EXC_HANDLER_EN
                size: 4
                desc:
                  '''
                  Whether or not the ROM should use the flash ECC exception
                  handler during execution. A value of kHardenedBoolTrue
                  allows the ROM to use an the exception handler that recovers
                  gracefully and continues the boot process if a flash ECC
                  error is encountered during verification of a specific
                  ROM_EXT slot. This enables the ROM to attempt booting the
                  next ROM_EXT slot if the first slot attempted has been
                  corrupted. All other values trigger default ROM exception
                  handling, which is all exceptions trigger a chip shutdown
                  and reset.
                  '''
                isdigest: false
                iszer: false
                ismubi: false
                iskeymgr_creator: false
                iskeymgr_owner: false
                absorb: false
                inv_default: 0
                offset: 944
              }
              {
                name: OWNER_SW_CFG_DIGEST
                size: 8
                offset: 976
                ismubi: false
                isdigest: true
                iszer: false
                inv_default: 18239385572812637686
                iskeymgr_creator: false
                iskeymgr_owner: false
              }
            ]
            desc:
              '''
              Software configuration partition.
              This contains data that changes software behavior in the ROM, for
              example enabling defensive features in ROM or selecting failure
              modes if verification fails.
              '''
            iskeymgr_creator: false
            iskeymgr_owner: false
            zeroizable: false
            ignore_read_lock_in_rma: false
            size: 584
            offset: 400
          }
          {
            name: OWNERSHIP_SLOT_STATE
            variant: Unbuffered
            absorb: false
            secret: false
            sw_digest: false
            hw_digest: false
            write_lock: None
            read_lock: CSR
            key_sel: NoKey
            integrity: true
            bkout_type: false
            zeroizable: true
            items:
            [
              {
                name: OWNERSHIP_SLOT_STATE_ZER
                size: 8
                offset: 984
                ismubi: false
                isdigest: false
                iszer: true
                inv_default: 0
                iskeymgr_creator: false
                iskeymgr_owner: false
              }
            ]
            iskeymgr_creator: false
            iskeymgr_owner: false
            ignore_read_lock_in_rma: false
            size: 8
            offset: 984
          }
          {
            name: ROT_OWNER_AUTH_SLOT0
            variant: Unbuffered
            absorb: false
            secret: false
            sw_digest: true
            hw_digest: false
            write_lock: Digest
            read_lock: CSR
            key_sel: NoKey
            integrity: true
            bkout_type: false
            zeroizable: true
            items:
            [
              {
                name: ROT_OWNER_AUTH_SLOT0_FIRMWARE_CODESIGN_KEY_TYPE
                size: 4
                desc:
                  '''
                  Key usage type. One of the following 32-bit values defined
                  by the sigverify API:
                  - kSigverifyKeyTypeTest for manufacturing, testing and RMA keys.
                    Keys of this type can be used only in TEST_UNLOCKED* and RMA life
                    cycle states.
                  - kSigverifyKeyTypeProd for production keys.
                    Keys of this type can be used in all operational life cycle states, i.e.
                    states in which CPU execution is enabled.
                  - kSigverifyKeyTypeDev for development keys.
                    Keys of this type can be used only in the DEV life cycle state.
                  '''
                isdigest: false
                iszer: false
                ismubi: false
                iskeymgr_creator: false
                iskeymgr_owner: false
                absorb: false
                inv_default: 0
                offset: 992
              }
              {
                name: ROT_OWNER_AUTH_SLOT0_FIRMWARE_CODESIGN_ECDSA_KEY
                size: 64
                desc:
                  '''
                  ECDSA public key used to verify firmware images.
                  Key Type: ECC NIST-P256 Curve.
                  It is expected to be provisioned at Final Test (FT) stage when LC = TEST_UNLOCKED.
                  '''
                isdigest: false
                iszer: false
                ismubi: false
                iskeymgr_creator: false
                iskeymgr_owner: false
                absorb: false
                inv_default: 0
                offset: 996
              }
              {
                name: ROT_OWNER_AUTH_SLOT0_FIRMWARE_CODESIGN_SPX_KEY
                size: 32
                desc:
                  '''
                  SPHINCS+ public key used to verify firmware images.
                  Key Type: SPHINCS+, see modes in ROT_OWNER_AUTH_SLOT0_FIRMWARE_CODESIGN_SPX_KEY_CONFIG.
                  It is expected to be provisioned at Final Test (FT) stage when LC = TEST_UNLOCKED.
                  '''
                isdigest: false
                iszer: false
                ismubi: false
                iskeymgr_creator: false
                iskeymgr_owner: false
                absorb: false
                inv_default: 0
                offset: 1060
              }
              {
                name: ROT_OWNER_AUTH_SLOT0_FIRMWARE_CODESIGN_SPX_KEY_CONFIG
                size: 4
                desc:
                  '''
                  Configuration value for ROT_OWNER_AUTH_SLOT0_FIRMWARE_CODESIGN_SPX_KEY:
                  - kSigverifySpxConfigIdSha2128s: SPHINCS+-SHA2-128s without pre-hashing.
                  - kSigverifySpxConfigIdSha2128sQ20: SPHINCS+-SHA2-128s-q20 without pre-hashing
                  - kSigverifySpxConfigIdSha2128sPrehash: SPHINCS+-SHA2-128s with SHA256 pre-hashing.
                  - kSigverifySpxConfigIdSha2128sQ20Prehash: SPHINCS+-SHA2-128s-q20 with SHA256 pre-hashing.
                  '''
                isdigest: false
                iszer: false
                ismubi: false
                iskeymgr_creator: false
                iskeymgr_owner: false
                absorb: false
                inv_default: 0
                offset: 1092
              }
              {
                name: ROT_OWNER_AUTH_SLOT0_DIGEST
                size: 8
                offset: 1096
                ismubi: false
                isdigest: true
                iszer: false
                inv_default: 7388996329285901817
                iskeymgr_creator: false
                iskeymgr_owner: false
              }
              {
                name: ROT_OWNER_AUTH_SLOT0_ZER
                size: 8
                offset: 1104
                ismubi: false
                isdigest: false
                iszer: true
                inv_default: 0
                iskeymgr_creator: false
                iskeymgr_owner: false
              }
            ]
            desc: Software managed partition for a RoT Owner (a.k.a. Silicon Creator) key manifest.
            iskeymgr_creator: false
            iskeymgr_owner: false
            ignore_read_lock_in_rma: false
            size: 120
            offset: 992
          }
          {
            name: ROT_OWNER_AUTH_SLOT1
            variant: Unbuffered
            absorb: false
            secret: false
            sw_digest: true
            hw_digest: false
            write_lock: Digest
            read_lock: CSR
            key_sel: NoKey
            integrity: true
            bkout_type: false
            zeroizable: true
            items:
            [
              {
                name: ROT_OWNER_AUTH_SLOT1_FIRMWARE_CODESIGN_KEY_TYPE
                size: 4
                desc:
                  '''
                  Key usage type. One of the following 32-bit values defined
                  by the sigverify API:
                  - kSigverifyKeyTypeTest for manufacturing, testing and RMA keys.
                    Keys of this type can be used only in TEST_UNLOCKED* and RMA life
                    cycle states.
                  - kSigverifyKeyTypeProd for production keys.
                    Keys of this type can be used in all operational life cycle states, i.e.
                    states in which CPU execution is enabled.
                  - kSigverifyKeyTypeDev for development keys.
                    Keys of this type can be used only in the DEV life cycle state.
                  '''
                isdigest: false
                iszer: false
                ismubi: false
                iskeymgr_creator: false
                iskeymgr_owner: false
                absorb: false
                inv_default: 0
                offset: 1112
              }
              {
                name: ROT_OWNER_AUTH_SLOT1_FIRMWARE_CODESIGN_ECDSA_KEY
                size: 64
                desc:
                  '''
                  ECDSA public key used to verify firmware images.
                  Key Type: ECC NIST-P256 Curve.
                  It is expected to be provisioned at Final Test (FT) stage when LC = TEST_UNLOCKED.
                  '''
                isdigest: false
                iszer: false
                ismubi: false
                iskeymgr_creator: false
                iskeymgr_owner: false
                absorb: false
                inv_default: 0
                offset: 1116
              }
              {
                name: ROT_OWNER_AUTH_SLOT1_FIRMWARE_CODESIGN_SPX_KEY
                size: 32
                desc:
                  '''
                  SPHINCS+ public key used to verify firmware images.
                  Key Type: SPHINCS+, see modes in ROT_OWNER_AUTH_SLOT1_FIRMWARE_CODESIGN_SPX_KEY_CONFIG.
                  It is expected to be provisioned at Final Test (FT) stage when LC = TEST_UNLOCKED.
                  '''
                isdigest: false
                iszer: false
                ismubi: false
                iskeymgr_creator: false
                iskeymgr_owner: false
                absorb: false
                inv_default: 0
                offset: 1180
              }
              {
                name: ROT_OWNER_AUTH_SLOT1_FIRMWARE_CODESIGN_SPX_KEY_CONFIG
                size: 4
                desc:
                  '''
                  Configuration value for ROT_OWNER_AUTH_SLOT1_FIRMWARE_CODESIGN_SPX_KEY:
                  - kSigverifySpxConfigIdSha2128s: SPHINCS+-SHA2-128s without pre-hashing.
                  - kSigverifySpxConfigIdSha2128sQ20: SPHINCS+-SHA2-128s-q20 without pre-hashing
                  - kSigverifySpxConfigIdSha2128sPrehash: SPHINCS+-SHA2-128s with SHA256 pre-hashing.
                  - kSigverifySpxConfigIdSha2128sQ20Prehash: SPHINCS+-SHA2-128s-q20 with SHA256 pre-hashing.
                  '''
                isdigest: false
                iszer: false
                ismubi: false
                iskeymgr_creator: false
                iskeymgr_owner: false
                absorb: false
                inv_default: 0
                offset: 1212
              }
              {
                name: ROT_OWNER_AUTH_SLOT1_DIGEST
                size: 8
                offset: 1216
                ismubi: false
                isdigest: true
                iszer: false
                inv_default: 17014664945089674915
                iskeymgr_creator: false
                iskeymgr_owner: false
              }
              {
                name: ROT_OWNER_AUTH_SLOT1_ZER
                size: 8
                offset: 1224
                ismubi: false
                isdigest: false
                iszer: true
                inv_default: 0
                iskeymgr_creator: false
                iskeymgr_owner: false
              }
            ]
            desc: Software managed partition for a RoT Owner (a.k.a. Silicon Creator) key manifest.
            iskeymgr_creator: false
            iskeymgr_owner: false
            ignore_read_lock_in_rma: false
            size: 120
            offset: 1112
          }
          {
            name: ROT_OWNER_AUTH_SLOT2
            variant: Unbuffered
            absorb: false
            secret: false
            sw_digest: true
            hw_digest: false
            write_lock: Digest
            read_lock: CSR
            key_sel: NoKey
            integrity: true
            bkout_type: false
            zeroizable: true
            items:
            [
              {
                name: ROT_OWNER_AUTH_SLOT2_FIRMWARE_CODESIGN_KEY_TYPE
                size: 4
                desc:
                  '''
                  Key usage type. One of the following 32-bit values defined
                  by the sigverify API:
                  - kSigverifyKeyTypeTest for manufacturing, testing and RMA keys.
                    Keys of this type can be used only in TEST_UNLOCKED* and RMA life
                    cycle states.
                  - kSigverifyKeyTypeProd for production keys.
                    Keys of this type can be used in all operational life cycle states, i.e.
                    states in which CPU execution is enabled.
                  - kSigverifyKeyTypeDev for development keys.
                    Keys of this type can be used only in the DEV life cycle state.
                  '''
                isdigest: false
                iszer: false
                ismubi: false
                iskeymgr_creator: false
                iskeymgr_owner: false
                absorb: false
                inv_default: 0
                offset: 1232
              }
              {
                name: ROT_OWNER_AUTH_SLOT2_FIRMWARE_CODESIGN_ECDSA_KEY
                size: 64
                desc:
                  '''
                  ECDSA public key used to verify firmware images.
                  Key Type: ECC NIST-P256 Curve.
                  It is expected to be provisioned at Final Test (FT) stage when LC = TEST_UNLOCKED.
                  '''
                isdigest: false
                iszer: false
                ismubi: false
                iskeymgr_creator: false
                iskeymgr_owner: false
                absorb: false
                inv_default: 0
                offset: 1236
              }
              {
                name: ROT_OWNER_AUTH_SLOT2_FIRMWARE_CODESIGN_SPX_KEY
                size: 32
                desc:
                  '''
                  SPHINCS+ public key used to verify firmware images.
                  Key Type: SPHINCS+, see modes in ROT_OWNER_AUTH_SLOT2_FIRMWARE_CODESIGN_SPX_KEY_CONFIG.
                  It is expected to be provisioned at Final Test (FT) stage when LC = TEST_UNLOCKED.
                  '''
                isdigest: false
                iszer: false
                ismubi: false
                iskeymgr_creator: false
                iskeymgr_owner: false
                absorb: false
                inv_default: 0
                offset: 1300
              }
              {
                name: ROT_OWNER_AUTH_SLOT2_FIRMWARE_CODESIGN_SPX_KEY_CONFIG
                size: 4
                desc:
                  '''
                  Configuration value for ROT_OWNER_AUTH_SLOT2_FIRMWARE_CODESIGN_SPX_KEY:
                  - kSigverifySpxConfigIdSha2128s: SPHINCS+-SHA2-128s without pre-hashing.
                  - kSigverifySpxConfigIdSha2128sQ20: SPHINCS+-SHA2-128s-q20 without pre-hashing
                  - kSigverifySpxConfigIdSha2128sPrehash: SPHINCS+-SHA2-128s with SHA256 pre-hashing.
                  - kSigverifySpxConfigIdSha2128sQ20Prehash: SPHINCS+-SHA2-128s-q20 with SHA256 pre-hashing.
                  '''
                isdigest: false
                iszer: false
                ismubi: false
                iskeymgr_creator: false
                iskeymgr_owner: false
                absorb: false
                inv_default: 0
                offset: 1332
              }
              {
                name: ROT_OWNER_AUTH_SLOT2_DIGEST
                size: 8
                offset: 1336
                ismubi: false
                isdigest: true
                iszer: false
                inv_default: 17787990554517712170
                iskeymgr_creator: false
                iskeymgr_owner: false
              }
              {
                name: ROT_OWNER_AUTH_SLOT2_ZER
                size: 8
                offset: 1344
                ismubi: false
                isdigest: false
                iszer: true
                inv_default: 0
                iskeymgr_creator: false
                iskeymgr_owner: false
              }
            ]
            desc: Software managed partition for a RoT Owner (a.k.a. Silicon Creator) key manifest.
            iskeymgr_creator: false
            iskeymgr_owner: false
            ignore_read_lock_in_rma: false
            size: 120
            offset: 1232
          }
          {
            name: ROT_OWNER_AUTH_SLOT3
            variant: Unbuffered
            absorb: false
            secret: false
            sw_digest: true
            hw_digest: false
            write_lock: Digest
            read_lock: CSR
            key_sel: NoKey
            integrity: true
            bkout_type: false
            zeroizable: true
            items:
            [
              {
                name: ROT_OWNER_AUTH_SLOT3_FIRMWARE_CODESIGN_KEY_TYPE
                size: 4
                desc:
                  '''
                  Key usage type. One of the following 32-bit values defined
                  by the sigverify API:
                  - kSigverifyKeyTypeTest for manufacturing, testing and RMA keys.
                    Keys of this type can be used only in TEST_UNLOCKED* and RMA life
                    cycle states.
                  - kSigverifyKeyTypeProd for production keys.
                    Keys of this type can be used in all operational life cycle states, i.e.
                    states in which CPU execution is enabled.
                  - kSigverifyKeyTypeDev for development keys.
                    Keys of this type can be used only in the DEV life cycle state.
                  '''
                isdigest: false
                iszer: false
                ismubi: false
                iskeymgr_creator: false
                iskeymgr_owner: false
                absorb: false
                inv_default: 0
                offset: 1352
              }
              {
                name: ROT_OWNER_AUTH_SLOT3_FIRMWARE_CODESIGN_ECDSA_KEY
                size: 64
                desc:
                  '''
                  ECDSA public key used to verify firmware images.
                  Key Type: ECC NIST-P256 Curve.
                  It is expected to be provisioned at Final Test (FT) stage when LC = TEST_UNLOCKED.
                  '''
                isdigest: false
                iszer: false
                ismubi: false
                iskeymgr_creator: false
                iskeymgr_owner: false
                absorb: false
                inv_default: 0
                offset: 1356
              }
              {
                name: ROT_OWNER_AUTH_SLOT3_FIRMWARE_CODESIGN_SPX_KEY
                size: 32
                desc:
                  '''
                  SPHINCS+ public key used to verify firmware images.
                  Key Type: SPHINCS+, see modes in ROT_OWNER_AUTH_SLOT3_FIRMWARE_CODESIGN_SPX_KEY_CONFIG.
                  It is expected to be provisioned at Final Test (FT) stage when LC = TEST_UNLOCKED.
                  '''
                isdigest: false
                iszer: false
                ismubi: false
                iskeymgr_creator: false
                iskeymgr_owner: false
                absorb: false
                inv_default: 0
                offset: 1420
              }
              {
                name: ROT_OWNER_AUTH_SLOT3_FIRMWARE_CODESIGN_SPX_KEY_CONFIG
                size: 4
                desc:
                  '''
                  Configuration value for ROT_OWNER_AUTH_SLOT3_FIRMWARE_CODESIGN_SPX_KEY:
                  - kSigverifySpxConfigIdSha2128s: SPHINCS+-SHA2-128s without pre-hashing.
                  - kSigverifySpxConfigIdSha2128sQ20: SPHINCS+-SHA2-128s-q20 without pre-hashing
                  - kSigverifySpxConfigIdSha2128sPrehash: SPHINCS+-SHA2-128s with SHA256 pre-hashing.
                  - kSigverifySpxConfigIdSha2128sQ20Prehash: SPHINCS+-SHA2-128s-q20 with SHA256 pre-hashing.
                  '''
                isdigest: false
                iszer: false
                ismubi: false
                iskeymgr_creator: false
                iskeymgr_owner: false
                absorb: false
                inv_default: 0
                offset: 1452
              }
              {
                name: ROT_OWNER_AUTH_SLOT3_DIGEST
                size: 8
                offset: 1456
                ismubi: false
                isdigest: true
                iszer: false
                inv_default: 13248414165649443033
                iskeymgr_creator: false
                iskeymgr_owner: false
              }
              {
                name: ROT_OWNER_AUTH_SLOT3_ZER
                size: 8
                offset: 1464
                ismubi: false
                isdigest: false
                iszer: true
                inv_default: 0
                iskeymgr_creator: false
                iskeymgr_owner: false
              }
            ]
            desc: Software managed partition for a RoT Owner (a.k.a. Silicon Creator) key manifest.
            iskeymgr_creator: false
            iskeymgr_owner: false
            ignore_read_lock_in_rma: false
            size: 120
            offset: 1352
          }
          {
            name: ROT_OWNER_AUTH_SLOT0_STATE
            variant: Unbuffered
            absorb: false
            secret: false
            sw_digest: true
            hw_digest: false
            write_lock: Digest
            read_lock: CSR
            key_sel: NoKey
            integrity: true
            bkout_type: false
            items:
            [
              {
                name: ROT_OWNER_AUTH_SLOT0_STATE_FIRMWARE_CODESIGN_ECDSA_KEY_STATE
                size: 4
                desc: Enablement state of the firmware verification ECDSA key in ROT_OWNER_AUTH_SLOT0.
                isdigest: false
                iszer: false
                ismubi: false
                iskeymgr_creator: false
                iskeymgr_owner: false
                absorb: false
                inv_default: 0
                offset: 1472
              }
              {
                name: ROT_OWNER_AUTH_SLOT0_STATE_FIRMWARE_CODESIGN_SPX_KEY_STATE
                size: 4
                desc: Enablement state of the firmware verification SPHINCS+ key in ROT_OWNER_AUTH_SLOT0.
                isdigest: false
                iszer: false
                ismubi: false
                iskeymgr_creator: false
                iskeymgr_owner: false
                absorb: false
                inv_default: 0
                offset: 1476
              }
              {
                name: ROT_OWNER_AUTH_SLOT0_STATE_DIGEST
                size: 8
                offset: 1480
                ismubi: false
                isdigest: true
                iszer: false
                inv_default: 5835184937972759951
                iskeymgr_creator: false
                iskeymgr_owner: false
              }
            ]
            desc:
              '''
              This OTP partition is used to capture the state of each key in ROT_OWNER_AUTH_SLOT0.
              Each key can be in one of the following states: BLANK, ENABLED, DISABLED. The
              encoded values are such that transitions between BLANK -> ENABLED ->  DISABLED are
              Possible without causing ECC errors (this is a mechanism similar to how we manage
              life cycle state transitions). The partition is left unlocked to allow STATE
              updates in the field. The ROM_EXT is required to lock access to the OTP Direct
              Access Interface to prevent DoS attacks from malicious code executing on Silicon
              Owner partitions. DAI write locking is available.
              '''
            iskeymgr_creator: false
            iskeymgr_owner: false
            zeroizable: false
            ignore_read_lock_in_rma: false
            size: 16
            offset: 1472
          }
          {
            name: ROT_OWNER_AUTH_SLOT1_STATE
            variant: Unbuffered
            absorb: false
            secret: false
            sw_digest: true
            hw_digest: false
            write_lock: Digest
            read_lock: CSR
            key_sel: NoKey
            integrity: true
            bkout_type: false
            items:
            [
              {
                name: ROT_OWNER_AUTH_SLOT1_STATE_FIRMWARE_CODESIGN_ECDSA_KEY_STATE
                size: 4
                desc: Enablement state of the firmware verification ECDSA key in ROT_OWNER_AUTH_SLOT1.
                isdigest: false
                iszer: false
                ismubi: false
                iskeymgr_creator: false
                iskeymgr_owner: false
                absorb: false
                inv_default: 0
                offset: 1488
              }
              {
                name: ROT_OWNER_AUTH_SLOT1_STATE_FIRMWARE_CODESIGN_SPX_KEY_STATE
                size: 4
                desc: Enablement state of the firmware verification SPHINCS+ key in ROT_OWNER_AUTH_SLOT1.
                isdigest: false
                iszer: false
                ismubi: false
                iskeymgr_creator: false
                iskeymgr_owner: false
                absorb: false
                inv_default: 0
                offset: 1492
              }
              {
                name: ROT_OWNER_AUTH_SLOT1_STATE_DIGEST
                size: 8
                offset: 1496
                ismubi: false
                isdigest: true
                iszer: false
                inv_default: 18410855119173665658
                iskeymgr_creator: false
                iskeymgr_owner: false
              }
            ]
            desc:
              '''
              This OTP partition is used to capture the state of each key in ROT_OWNER_AUTH_SLOT1.
              Each key can be in one of the following states: BLANK, ENABLED, DISABLED. The
              encoded values are such that transitions between BLANK -> ENABLED ->  DISABLED are
              Possible without causing ECC errors (this is a mechanism similar to how we manage
              life cycle state transitions). The partition is left unlocked to allow STATE
              updates in the field. The ROM_EXT is required to lock access to the OTP Direct
              Access Interface to prevent DoS attacks from malicious code executing on Silicon
              Owner partitions. DAI write locking is available.
              '''
            iskeymgr_creator: false
            iskeymgr_owner: false
            zeroizable: false
            ignore_read_lock_in_rma: false
            size: 16
            offset: 1488
          }
          {
            name: ROT_OWNER_AUTH_SLOT2_STATE
            variant: Unbuffered
            absorb: false
            secret: false
            sw_digest: true
            hw_digest: false
            write_lock: Digest
            read_lock: CSR
            key_sel: NoKey
            integrity: true
            bkout_type: false
            items:
            [
              {
                name: ROT_OWNER_AUTH_SLOT2_STATE_FIRMWARE_CODESIGN_ECDSA_KEY_STATE
                size: 4
                desc: Enablement state of the firmware verification ECDSA key in ROT_OWNER_AUTH_SLOT2.
                isdigest: false
                iszer: false
                ismubi: false
                iskeymgr_creator: false
                iskeymgr_owner: false
                absorb: false
                inv_default: 0
                offset: 1504
              }
              {
                name: ROT_OWNER_AUTH_SLOT2_STATE_FIRMWARE_CODESIGN_SPX_KEY_STATE
                size: 4
                desc: Enablement state of the firmware verification SPHINCS+ key in ROT_OWNER_AUTH_SLOT2.
                isdigest: false
                iszer: false
                ismubi: false
                iskeymgr_creator: false
                iskeymgr_owner: false
                absorb: false
                inv_default: 0
                offset: 1508
              }
              {
                name: ROT_OWNER_AUTH_SLOT2_STATE_DIGEST
                size: 8
                offset: 1512
                ismubi: false
                isdigest: true
                iszer: false
                inv_default: 17765946314086229411
                iskeymgr_creator: false
                iskeymgr_owner: false
              }
            ]
            desc:
              '''
              This OTP partition is used to capture the state of each key in ROT_OWNER_AUTH_SLOT2.
              Each key can be in one of the following states: BLANK, ENABLED, DISABLED. The
              encoded values are such that transitions between BLANK -> ENABLED ->  DISABLED are
              Possible without causing ECC errors (this is a mechanism similar to how we manage
              life cycle state transitions). The partition is left unlocked to allow STATE
              updates in the field. The ROM_EXT is required to lock access to the OTP Direct
              Access Interface to prevent DoS attacks from malicious code executing on Silicon
              Owner partitions. DAI write locking is available.
              '''
            iskeymgr_creator: false
            iskeymgr_owner: false
            zeroizable: false
            ignore_read_lock_in_rma: false
            size: 16
            offset: 1504
          }
          {
            name: ROT_OWNER_AUTH_SLOT3_STATE
            variant: Unbuffered
            absorb: false
            secret: false
            sw_digest: true
            hw_digest: false
            write_lock: Digest
            read_lock: CSR
            key_sel: NoKey
            integrity: true
            bkout_type: false
            items:
            [
              {
                name: ROT_OWNER_AUTH_SLOT3_STATE_FIRMWARE_CODESIGN_ECDSA_KEY_STATE
                size: 4
                desc: Enablement state of the firmware verification ECDSA key in ROT_OWNER_AUTH_SLOT3.
                isdigest: false
                iszer: false
                ismubi: false
                iskeymgr_creator: false
                iskeymgr_owner: false
                absorb: false
                inv_default: 0
                offset: 1520
              }
              {
                name: ROT_OWNER_AUTH_SLOT3_STATE_FIRMWARE_CODESIGN_SPX_KEY_STATE
                size: 4
                desc: Enablement state of the firmware verification SPHINCS+ key in ROT_OWNER_AUTH_SLOT3.
                isdigest: false
                iszer: false
                ismubi: false
                iskeymgr_creator: false
                iskeymgr_owner: false
                absorb: false
                inv_default: 0
                offset: 1524
              }
              {
                name: ROT_OWNER_AUTH_SLOT3_STATE_DIGEST
                size: 8
                offset: 1528
                ismubi: false
                isdigest: true
                iszer: false
                inv_default: 5776996463561863949
                iskeymgr_creator: false
                iskeymgr_owner: false
              }
            ]
            desc:
              '''
              This OTP partition is used to capture the state of each key in ROT_OWNER_AUTH_SLOT3.
              Each key can be in one of the following states: BLANK, ENABLED, DISABLED. The
              encoded values are such that transitions between BLANK -> ENABLED ->  DISABLED are
              Possible without causing ECC errors (this is a mechanism similar to how we manage
              life cycle state transitions). The partition is left unlocked to allow STATE
              updates in the field. The ROM_EXT is required to lock access to the OTP Direct
              Access Interface to prevent DoS attacks from malicious code executing on Silicon
              Owner partitions. DAI write locking is available.
              '''
            iskeymgr_creator: false
            iskeymgr_owner: false
            zeroizable: false
            ignore_read_lock_in_rma: false
            size: 16
            offset: 1520
          }
          {
            name: SCRATCH_FUSES
            variant: Unbuffered
            absorb: true
            secret: false
            sw_digest: false
            hw_digest: false
            write_lock: None
            read_lock: CSR
            key_sel: NoKey
            integrity: true
            bkout_type: false
            zeroizable: true
            items:
            [
              {
                name: SCRATCH_FUSES_DATA
                absorb: true
                desc:
                  '''
                  Fully SW managed partition.
                  Unstructured, single item partition for any RoT firmware (runtime,
                  bootstrap, manufacturing) to use and organize freely.
                  '''
                size: 16
                isdigest: false
                iszer: false
                ismubi: false
                iskeymgr_creator: false
                iskeymgr_owner: false
                inv_default: 0
                offset: 1536
              }
              {
                name: SCRATCH_FUSES_ZER
                size: 8
                offset: 1552
                ismubi: false
                isdigest: false
                iszer: true
                inv_default: 0
                iskeymgr_creator: false
                iskeymgr_owner: false
              }
            ]
            desc: Unstructured scratch data partition.
            iskeymgr_creator: false
            iskeymgr_owner: false
            ignore_read_lock_in_rma: false
            size: 24
            offset: 1536
          }
          {
            name: HW_CFG0
            variant: Buffered
            secret: false
            sw_digest: false
            hw_digest: true
            write_lock: Digest
            read_lock: None
            key_sel: NoKey
            integrity: true
            bkout_type: true
            skip_sw_header: true
            items:
            [
              {
                name: DEVICE_ID
                size: 32
                inv_default: 75416344968344595199184561357653563771667887286318218849004063607029244022168
                desc:
                  '''
                  Unique device identifier that is always exposed through the
                  lifecycle JTAG tap. See documentation on Device Identifiers.
                  '''
                isdigest: false
                iszer: false
                ismubi: false
                iskeymgr_creator: false
                iskeymgr_owner: false
                absorb: false
                offset: 1560
              }
              {
                name: HW_CFG0_DIGEST
                size: 8
                offset: 1592
                ismubi: false
                isdigest: true
                iszer: false
                inv_default: 16772361003296535520
                iskeymgr_creator: false
                iskeymgr_owner: false
              }
            ]
            desc:
              '''
              Hardware configuration 0 partition.
              This contains a device identifier and manufacturing state.
              '''
            absorb: false
            iskeymgr_creator: false
            iskeymgr_owner: false
            zeroizable: false
            ignore_read_lock_in_rma: false
            size: 40
            offset: 1560
          }
          {
            name: HW_CFG1
            variant: Buffered
            secret: false
            sw_digest: false
            hw_digest: true
            write_lock: Digest
            read_lock: None
            key_sel: NoKey
            integrity: true
            bkout_type: true
            skip_sw_header: true
            items:
            [
              {
                name: EN_SRAM_IFETCH
                size: 1
                ismubi: true
                inv_default: 105
                desc:
                  '''
                  Enablement of execute from SRAM switch in the sram_ctrl (see
                  EXEC CSR). A kMultiBitBool8True value enables, while all
                  other values disable.
                  '''
                isdigest: false
                iszer: false
                iskeymgr_creator: false
                iskeymgr_owner: false
                absorb: false
                offset: 1600
              }
              {
                name: EN_CSRNG_SW_APP_READ
                size: 1
                ismubi: true
                inv_default: 105
                desc:
                  '''
                  Enablement of CSRNG software application interface. A
                  kMultiBitBool8True value enables, while all other values
                  disable. Enablement is required to extract output from
                  CSRNG via software.
                  '''
                isdigest: false
                iszer: false
                iskeymgr_creator: false
                iskeymgr_owner: false
                absorb: false
                offset: 1601
              }
              {
                name: DIS_RV_DM_LATE_DEBUG
                size: 1
                ismubi: true
                inv_default: 105
                desc:
                  '''
                  Disablement of RV_DM late debug feature (see rv_dm
                  documentation). A kMultiBitBool8True disables the late debug
                  feature and renders the rv_dm fully ungated in DEV lifecycle
                  states. All other values gate rv_dm reachability based on
                  the value of LATE_DEBUG_ENABLE CSR in the rv_dm block.
                  '''
                isdigest: false
                iszer: false
                iskeymgr_creator: false
                iskeymgr_owner: false
                absorb: false
                offset: 1602
              }
              {
                name: HW_CFG1_DIGEST
                size: 8
                offset: 1608
                ismubi: false
                isdigest: true
                iszer: false
                inv_default: 16239032379200962209
                iskeymgr_creator: false
                iskeymgr_owner: false
              }
            ]
            desc:
              '''
              Hardware configuration 1 partition.
              This contains several hardware feature switches.
              '''
            absorb: false
            iskeymgr_creator: false
            iskeymgr_owner: false
            zeroizable: false
            ignore_read_lock_in_rma: false
            size: 16
            offset: 1600
          }
          {
            name: HW_CFG2
            variant: Buffered
            secret: false
            sw_digest: false
            hw_digest: true
            write_lock: Digest
            read_lock: None
            key_sel: NoKey
            integrity: true
            bkout_type: true
            zeroizable: true
            items:
            [
              {
                name: MANUF_STATE
                size: 32
                inv_default: 74703898927885615228644073031729127987260023218980427977577683364343954231749
                desc: Field to capture the manufacturing state.
                isdigest: false
                iszer: false
                ismubi: false
                iskeymgr_creator: false
                iskeymgr_owner: false
                absorb: false
                offset: 1616
              }
              {
                name: HW_CFG2_DIGEST
                size: 8
                offset: 1648
                ismubi: false
                isdigest: true
                iszer: false
                inv_default: 6748737775371490481
                iskeymgr_creator: false
                iskeymgr_owner: false
              }
              {
                name: HW_CFG2_ZER
                size: 8
                offset: 1656
                ismubi: false
                isdigest: false
                iszer: true
                inv_default: 0
                iskeymgr_creator: false
                iskeymgr_owner: false
              }
            ]
            desc:
              '''
              Hardware configuration partition 2.
              This contains the manufacturing state.
              '''
            absorb: false
            iskeymgr_creator: false
            iskeymgr_owner: false
            ignore_read_lock_in_rma: false
            size: 48
            offset: 1616
          }
          {
            name: SECRET0
            variant: Buffered
            secret: true
            sw_digest: false
            hw_digest: true
            write_lock: Digest
            read_lock: Digest
            ignore_read_lock_in_rma: true
            key_sel: Secret0Key
            integrity: true
            bkout_type: false
            skip_sw_header: true
            items:
            [
              {
                name: TEST_UNLOCK_TOKEN
                inv_default: 230748029623541578864187550162391519735
                size: 16
                isdigest: false
                iszer: false
                ismubi: false
                iskeymgr_creator: false
                iskeymgr_owner: false
                absorb: false
                offset: 1664
              }
              {
                name: TEST_EXIT_TOKEN
                inv_default: 335469059873213918850882942343750995942
                size: 16
                isdigest: false
                iszer: false
                ismubi: false
                iskeymgr_creator: false
                iskeymgr_owner: false
                absorb: false
                offset: 1680
              }
              {
                name: SECRET0_DIGEST
                size: 8
                offset: 1696
                ismubi: false
                isdigest: true
                iszer: false
                inv_default: 7532579203220097263
                iskeymgr_creator: false
                iskeymgr_owner: false
              }
            ]
            desc:
              '''
              Secret partition 0.
              This contains TEST lifecycle unlock tokens.
              '''
            absorb: false
            iskeymgr_creator: false
            iskeymgr_owner: false
            zeroizable: false
            size: 40
            offset: 1664
          }
          {
            name: SECRET1
            variant: Buffered
            secret: true
            sw_digest: false
            hw_digest: true
            write_lock: Digest
            read_lock: Digest
            ignore_read_lock_in_rma: true
            key_sel: Secret1Key
            integrity: true
            bkout_type: false
            skip_sw_header: true
            items:
            [
              {
                name: FLASH_ADDR_KEY_SEED
                inv_default: 23531955425096136348941735642650773479001928178605645757494297030518339325231
                size: 32
                isdigest: false
                iszer: false
                ismubi: false
                iskeymgr_creator: false
                iskeymgr_owner: false
                absorb: false
                offset: 1704
              }
              {
                name: FLASH_DATA_KEY_SEED
                inv_default: 7536910898370239450524093328085871963862640062161248607096610222518662706945
                size: 32
                isdigest: false
                iszer: false
                ismubi: false
                iskeymgr_creator: false
                iskeymgr_owner: false
                absorb: false
                offset: 1736
              }
              {
                name: SRAM_DATA_KEY_SEED
                inv_default: 334671433878751700697199779069205613746
                size: 16
                isdigest: false
                iszer: false
                ismubi: false
                iskeymgr_creator: false
                iskeymgr_owner: false
                absorb: false
                offset: 1768
              }
              {
                name: SECRET1_DIGEST
                size: 8
                offset: 1784
                ismubi: false
                isdigest: true
                iszer: false
                inv_default: 12018756830038280371
                iskeymgr_creator: false
                iskeymgr_owner: false
              }
            ]
            desc:
              '''
              Secret partition 1.
              This contains SRAM and flash scrambling keys.
              '''
            absorb: false
            iskeymgr_creator: false
            iskeymgr_owner: false
            zeroizable: false
            size: 88
            offset: 1704
          }
          {
            name: SECRET2
            variant: Buffered
            secret: true
            sw_digest: false
            hw_digest: true
            write_lock: Digest
            read_lock: Digest
            ignore_read_lock_in_rma: true
            key_sel: Secret2Key
            integrity: true
            bkout_type: false
            skip_sw_header: true
            items:
            [
              {
                name: RMA_TOKEN
                inv_default: 130971651290035026448304299560793978178
                size: 16
                isdigest: false
                iszer: false
                ismubi: false
                iskeymgr_creator: false
                iskeymgr_owner: false
                absorb: false
                offset: 1792
              }
              {
                name: CREATOR_ROOT_KEY_SHARE0
                inv_default: 92348881548169349828605117641018822276568973017337749653532230513078504803567
                size: 32
                iskeymgr_creator: true
                isdigest: false
                iszer: false
                ismubi: false
                iskeymgr_owner: false
                absorb: false
                offset: 1808
              }
              {
                name: CREATOR_ROOT_KEY_SHARE1
                inv_default: 33599205987092681210239649990958622833804933314610392317109421837165274603539
                size: 32
                iskeymgr_creator: true
                isdigest: false
                iszer: false
                ismubi: false
                iskeymgr_owner: false
                absorb: false
                offset: 1840
              }
              {
                name: CREATOR_SEED
                inv_default: 42840131334136411941200644947425579008419079534194068434596656023607238656790
                size: 32
                iskeymgr_creator: true
                desc:
                  '''
                  Random seed value generated at manufacturing time for FIPS-compliance
                  when deriving the creator root keys during boot.
                  '''
                isdigest: false
                iszer: false
                ismubi: false
                iskeymgr_owner: false
                absorb: false
                offset: 1872
              }
              {
                name: SECRET2_DIGEST
                size: 8
                offset: 1904
                ismubi: false
                isdigest: true
                iszer: false
                inv_default: 13961193720981549769
                iskeymgr_creator: false
                iskeymgr_owner: false
              }
            ]
            desc:
              '''
              Secret partition 2.
              This contains RMA unlock token, creator root key, and creator seed.
              '''
            absorb: false
            iskeymgr_creator: true
            iskeymgr_owner: false
            zeroizable: false
            size: 120
            offset: 1792
          }
          {
            name: SECRET3
            variant: Buffered
            secret: true
            sw_digest: false
            hw_digest: true
            write_lock: Digest
            read_lock: Digest
            key_sel: Secret3Key
            integrity: true
            bkout_type: false
            zeroizable: true
            skip_sw_header: true
            items:
            [
              {
                name: OWNER_SEED
                inv_default: 46917961507141145256060626454085849401363337700765221407992884200406625985337
                size: 32
                iskeymgr_owner: true
                desc:
                  '''
                  Random seed value generated at manufacturing time for FIPS-compliance
                  when deriving the owner keys during boot.
                  '''
                isdigest: false
                iszer: false
                ismubi: false
                iskeymgr_creator: false
                absorb: false
                offset: 1912
              }
              {
                name: SECRET3_DIGEST
                size: 8
                offset: 1944
                ismubi: false
                isdigest: true
                iszer: false
                inv_default: 354744590412343289
                iskeymgr_creator: false
                iskeymgr_owner: false
              }
              {
                name: SECRET3_ZER
                size: 8
                offset: 1952
                ismubi: false
                isdigest: false
                iszer: true
                inv_default: 0
                iskeymgr_creator: false
                iskeymgr_owner: false
              }
            ]
            desc:
              '''
              Secret partition 3.
              This contains the owner intermediate and owner seeds.
              '''
            absorb: false
            iskeymgr_creator: false
            iskeymgr_owner: true
            ignore_read_lock_in_rma: false
            size: 48
            offset: 1912
          }
          {
            name: LIFE_CYCLE
            variant: LifeCycle
            secret: false
            sw_digest: false
            hw_digest: false
            write_lock: None
            read_lock: None
            key_sel: NoKey
            integrity: true
            bkout_type: false
            skip_sw_header: true
            items:
            [
              {
                name: LC_TRANSITION_CNT
                inv_default: 6707296131048348035660209850454458516403716907741954216822891807334833183171263528798563328586680206667318424192181
                size: 48
                isdigest: false
                iszer: false
                ismubi: false
                iskeymgr_creator: false
                iskeymgr_owner: false
                absorb: false
                offset: 1960
              }
              {
                name: LC_STATE
                inv_default: 150724158863578290761376796642879324047970044817803993230695865344826642621771004974996689303386
                size: 40
                isdigest: false
                iszer: false
                ismubi: false
                iskeymgr_creator: false
                iskeymgr_owner: false
                absorb: false
                offset: 2008
              }
            ]
            desc:
              '''
              Lifecycle partition.
              This contains lifecycle transition count and state. This partition
              cannot be locked since the life cycle state needs to advance to RMA
              in-field. Note that while this partition is not marked secret, it
              is not readable nor writeable via the DAI. Only the LC controller
              can access this partition, and even via the LC controller it is not
              possible to read the raw manufacturing life cycle state in encoded
              form, since that encoding is considered a netlist secret. The LC
              controller only exposes a decoded version of this state.
              '''
            absorb: false
            iskeymgr_creator: false
            iskeymgr_owner: false
            zeroizable: false
            ignore_read_lock_in_rma: false
            size: 88
            offset: 1960
          }
        ]
      }
    }
    {
      name: lc_ctrl
      type: lc_ctrl
      base_addrs:
      {
        regs:
        {
          hart: 0x40140000
        }
        dmi:
        {
          hart: 0x0
        }
      }
      memory: {}
      param_list:
      [
        {
          name: RndCnstLcKeymgrDivInvalid
          desc: Diversification value used for all invalid life cycle states.
          type: lc_ctrl_pkg::lc_keymgr_div_t
          randcount: 128
          randtype: data
          name_top: RndCnstLcCtrlLcKeymgrDivInvalid
          default: 0xf33b479718558e6759764645aad1fb21
          randwidth: 128
        }
        {
          name: RndCnstLcKeymgrDivTestUnlocked
          desc: Diversification value used for the TEST_UNLOCKED* life cycle states.
          type: lc_ctrl_pkg::lc_keymgr_div_t
          randcount: 128
          randtype: data
          name_top: RndCnstLcCtrlLcKeymgrDivTestUnlocked
          default: 0xc18124635e3d50a88f6808045627ac18
          randwidth: 128
        }
        {
          name: RndCnstLcKeymgrDivDev
          desc: Diversification value used for the DEV life cycle state.
          type: lc_ctrl_pkg::lc_keymgr_div_t
          randcount: 128
          randtype: data
          name_top: RndCnstLcCtrlLcKeymgrDivDev
          default: 0xf377d9071beca6f194ef96f3e535b58f
          randwidth: 128
        }
        {
          name: RndCnstLcKeymgrDivProduction
          desc: Diversification value used for the PROD/PROD_END life cycle states.
          type: lc_ctrl_pkg::lc_keymgr_div_t
          randcount: 128
          randtype: data
          name_top: RndCnstLcCtrlLcKeymgrDivProduction
          default: 0x2adad82b175fe9ea1c326a6610c11177
          randwidth: 128
        }
        {
          name: RndCnstLcKeymgrDivRma
          desc: Diversification value used for the RMA life cycle state.
          type: lc_ctrl_pkg::lc_keymgr_div_t
          randcount: 128
          randtype: data
          name_top: RndCnstLcCtrlLcKeymgrDivRma
          default: 0x44de61ccbfabd3e1fda667e04082478c
          randwidth: 128
        }
        {
          name: RndCnstInvalidTokens
          desc: Compile-time random bits used for invalid tokens in the token mux
          type: lc_ctrl_pkg::lc_token_mux_t
          randcount: 1024
          randtype: data
          name_top: RndCnstLcCtrlInvalidTokens
          default: 0x14db070a6129bb2945b88dc6cfcf2ae02f47010cb666a5e22d3320f89caa47e5ced5d29cc9cdb468773ebacec14da34c505aedc70ea184c7a34193d59c735b5b4e2cbee5ab93cb024d6f8c0c700110cbf01425daf5141df19a882a71d66b5953dbc603379da9efb2069bd79815b2f8d99a40e7fdc4fb13143d7753ce1cf9e202
          randwidth: 1024
        }
      ]
    }
    {
      name: alert_handler
      type: alert_handler
      base_addrs:
      {
        null:
        {
          hart: 0x40150000
        }
      }
      memory: {}
      param_list:
      [
        {
          name: RndCnstLfsrSeed
          desc: Compile-time random bits for initial LFSR seed
          type: alert_handler_pkg::lfsr_seed_t
          randcount: 32
          randtype: data
          name_top: RndCnstAlertHandlerLfsrSeed
          default: 0x92073969
          randwidth: 32
        }
        {
          name: RndCnstLfsrPerm
          desc: Compile-time random permutation for LFSR output
          type: alert_handler_pkg::lfsr_perm_t
          randcount: 32
          randtype: perm
          name_top: RndCnstAlertHandlerLfsrPerm
          default: 0x263d4e08d27db7d2fc60644ed4e9d00d6ea9af28
          randwidth: 160
        }
      ]
      template_type: alert_handler
    }
    {
      name: sram_ctrl_ret_aon
      type: sram_ctrl
      base_addrs:
      {
        regs:
        {
          hart: 0x40500000
        }
        ram:
        {
          hart: 0x40600000
        }
      }
      memory:
      {
        ram:
        {
          label: ram_ret_aon
          swaccess: rw
          data_intg_passthru: True
          exec: True
          byte_write: True
          size: 0x1000
        }
      }
      param_list:
      [
        {
          name: RndCnstSramKey
          desc: Compile-time random reset value for SRAM scrambling key.
          type: otp_ctrl_pkg::sram_key_t
          randcount: 128
          randtype: data
          name_top: RndCnstSramCtrlRetAonSramKey
          default: 0x818054e0e0edb0acd0b040fc629ea7f8
          randwidth: 128
        }
        {
          name: RndCnstSramNonce
          desc: Compile-time random reset value for SRAM scrambling nonce.
          type: otp_ctrl_pkg::sram_nonce_t
          randcount: 128
          randtype: data
          name_top: RndCnstSramCtrlRetAonSramNonce
          default: 0xb17fa88fee02e3f0864223a2e23a8cc3
          randwidth: 128
        }
        {
          name: RndCnstLfsrSeed
          desc: Compile-time random bits for initial LFSR seed
          type: sram_ctrl_pkg::lfsr_seed_t
          randcount: 64
          randtype: data
          name_top: RndCnstSramCtrlRetAonLfsrSeed
          default: 0x1e2de5e578d43d2d
          randwidth: 64
        }
        {
          name: RndCnstLfsrPerm
          desc: Compile-time random permutation for LFSR output
          type: sram_ctrl_pkg::lfsr_perm_t
          randcount: 64
          randtype: perm
          name_top: RndCnstSramCtrlRetAonLfsrPerm
          default: 0x386782526c4bd5d1721f403af01a106603d70d61369ea24d8ccbafb24c3be61a51f885627caf5b4da737ae5b7f6384b3
          randwidth: 384
        }
      ]
    }
    {
      name: flash_ctrl
      type: flash_ctrl
      base_addrs:
      {
        core:
        {
          hart: 0x41000000
        }
        mem:
        {
          hart: 0x20000000
        }
      }
      memory:
      {
        mem:
        {
          label: eflash
          swaccess: ro
          data_intg_passthru: True
          exec: True
          byte_write: False
          config:
          {
            banks: 2
            data_width: 64
            info_types: 3
            infos_per_bank:
            [
              10
              1
              2
            ]
            pages_per_bank: 256
            program_resolution: 8
            size: 0x100000
            words_per_page: 256
          }
          size: 0x100000
        }
      }
      param_list:
      [
        {
          name: RndCnstAddrKey
          desc: Compile-time random bits for default address key
          type: flash_ctrl_pkg::flash_key_t
          randcount: 128
          randtype: data
          name_top: RndCnstFlashCtrlAddrKey
          default: 0x7118af11cdbe78d67060615a20b9c074
          randwidth: 128
        }
        {
          name: RndCnstDataKey
          desc: Compile-time random bits for default data key
          type: flash_ctrl_pkg::flash_key_t
          randcount: 128
          randtype: data
          name_top: RndCnstFlashCtrlDataKey
          default: 0xf07969ccd2d10a1a6e7988fa528ac03
          randwidth: 128
        }
        {
          name: RndCnstAllSeeds
          desc: Compile-time random bits for default seeds
          type: flash_ctrl_top_specific_pkg::all_seeds_t
          randcount: 512
          randtype: data
          name_top: RndCnstFlashCtrlAllSeeds
          default: 0x2e0a6138cb8316ff95c65cd7a1a768b06e0106d60eda0f1bc67adf85bd9a56ea088d33ffaa6a1155afb0169ab2de3973d027ee30b8f901f644ec7cd3e56c8ed1
          randwidth: 512
        }
        {
          name: RndCnstLfsrSeed
          desc: Compile-time random bits for initial LFSR seed
          type: flash_ctrl_top_specific_pkg::lfsr_seed_t
          randcount: 32
          randtype: data
          name_top: RndCnstFlashCtrlLfsrSeed
          default: 0xec38739f
          randwidth: 32
        }
        {
          name: RndCnstLfsrPerm
          desc: Compile-time random permutation for LFSR output
          type: flash_ctrl_top_specific_pkg::lfsr_perm_t
          randcount: 32
          randtype: perm
          name_top: RndCnstFlashCtrlLfsrPerm
          default: 0x5abe833e7960bac9a24bee9c5892a6cd0e7f423
          randwidth: 160
        }
      ]
      template_type: flash_ctrl
    }
    {
      name: acc
      type: acc
      base_addrs:
      {
        null:
        {
          hart: 0x41300000
        }
      }
      memory: {}
      param_list:
      [
        {
          name: RndCnstUrndPrngSeed
          desc: Default seed of the PRNG used for URND.
          type: acc_pkg::urnd_prng_seed_t
          randcount: 256
          randtype: data
          name_top: RndCnstAccUrndPrngSeed
          default: 0xf31a0165939d819d1518690e6473cdb2479391635057ca1045b9e1917e1ff018
          randwidth: 256
        }
        {
          name: RndCnstAccKey
          desc: Compile-time random reset value for IMem/DMem scrambling key.
          type: otp_ctrl_pkg::acc_key_t
          randcount: 128
          randtype: data
          name_top: RndCnstAccAccKey
          default: 0x9b04a4f7fba960fe098a4fb9d469171b
          randwidth: 128
        }
        {
          name: RndCnstAccNonce
          desc: Compile-time random reset value for IMem/DMem scrambling nonce.
          type: otp_ctrl_pkg::acc_nonce_t
          randcount: 64
          randtype: data
          name_top: RndCnstAccAccNonce
          default: 0x950e364b0dac5469
          randwidth: 64
        }
      ]
    }
    {
      name: aes
      type: aes
      base_addrs:
      {
        null:
        {
          hart: 0x41100000
        }
      }
      memory: {}
      param_list:
      [
        {
          name: RndCnstClearingLfsrSeed
          desc: Default seed of the PRNG used for register clearing.
          type: aes_pkg::clearing_lfsr_seed_t
          randcount: 64
          randtype: data
          name_top: RndCnstAesClearingLfsrSeed
          default: 0x568e661498fd8919
          randwidth: 64
        }
        {
          name: RndCnstClearingLfsrPerm
          desc: Permutation applied to the LFSR of the PRNG used for clearing.
          type: aes_pkg::clearing_lfsr_perm_t
          randcount: 64
          randtype: perm
          name_top: RndCnstAesClearingLfsrPerm
          default: 0xe771e48edd529ceef4ba8348320e092809566557137842e1f856b3994622a46ac1fdd0fc45b3f65eac6cbf0402f7ac9f
          randwidth: 384
        }
        {
          name: RndCnstClearingSharePerm
          desc: Permutation applied to the clearing PRNG output for clearing the second share of registers.
          type: aes_pkg::clearing_lfsr_perm_t
          randcount: 64
          randtype: perm
          name_top: RndCnstAesClearingSharePerm
          default: 0x49f2a3b24cd710cff8bbacbd1f4a000eb465ab90a619e716171ee077c6ef3b6609f990502143cdddab69867d5388bc15
          randwidth: 384
        }
        {
          name: RndCnstMaskingLfsrSeed
          desc: Default seed of the PRNG used for masking.
          type: aes_pkg::masking_lfsr_seed_t
          randcount: 288
          randtype: data
          name_top: RndCnstAesMaskingLfsrSeed
          default: 0xd58dc65508e869af565c1b87d687ee837fc119f5bbe7395cac38919c27006c23e142591
          randwidth: 288
        }
        {
          name: RndCnstMaskingLfsrPerm
          desc: Permutation applied to the output of the PRNG used for masking.
          type: aes_pkg::masking_lfsr_perm_t
          randcount: 160
          randtype: perm
          name_top: RndCnstAesMaskingLfsrPerm
          default: 0x32633b8d506a4f98923391351311550c70390a4361769a74294b7887219b8e682e622c2671730f9610867c1589371823204654858c4c4909803416641a192d064a811f9f99414d5f450b17565360827277036c27053c837a8b5a318a9e2b14120744471c5c3d84300e5e586f3e2f389769367e9d9c656d027b88578f7f93661d791e4890592524281b956b3f525b0d420194517d3a006e67224e5d752a044008
          randwidth: 1280
        }
      ]
    }
    {
      name: kmac
      type: kmac
      base_addrs:
      {
        null:
        {
          hart: 0x41120000
        }
      }
      memory: {}
      param_list:
      [
        {
          name: RndCnstLfsrSeed
          desc: Compile-time random data for PRNG default seed
          type: kmac_pkg::lfsr_seed_t
          randcount: 288
          randtype: data
          name_top: RndCnstKmacLfsrSeed
          default: 0xca534911723e1ea0687402a816510c535a8164939d97df7421ad4d2c18b270d422ec39c
          randwidth: 288
        }
        {
          name: RndCnstLfsrPerm
          desc: Compile-time random permutation for PRNG output
          type: kmac_pkg::lfsr_perm_t
          randcount: 800
          randtype: perm
          name_top: RndCnstKmacLfsrPerm
          default: 0x9fd5d3ace7966bdc2922a3946b9c1cac4e218a3469cf5272588602c1f83e0181e53267bc5841a1b5a9cac86a64ac8fa9f69f7b0fe6f89a74e0176c6b3c56784eb4c5dc4c38447acdb1c0ee7c62d97d3a9111f93ed2ab4d8884a7430960ddda5960e9cd6b704a302646455831ecd71dd8501edb9eab06ced86a999a25754094f6a58cc3e4843d353782f61d1d41a386e283549fa42718131230167452ede7fdf300e049c2200a4016d1e1648c8bbc028c47832a24012cb5cca03a072a650030236a40d09989e5e57dab05f22e0068dc259ac8261e34d1203361687f108b1a277a5c71825c65d83059a375479815bc745cbb51a0830b1b9cd946ff9944b050f05c5141bec51c66aa6e355a0ae3eeab5f15a18f0324e56a45fe605e4781ae619ee7290505e412d9f6352123d0eab656f75028732338febb6dd7844af9bb19051155c7c114f67e2662a5013fa4957c457b51715442f738cf896e232aa11bf65a3b5bdaccb7a86b9b1df24783aa96fbba8dcc31267882da367216aa603118c15bfb2a6884197c19047a713b446d0c93792663bf2e09d7020566d26e303316c738c4816179552a0d4ad2c2d665a0a1f1d22e5e8695cf074a4542ae3fcb108ea82caa4585df5c2df3f4e564c16bbaf693a848097a473097e2f8aa9b609aa39ddfc7f46c2464511d0a870f35ddc01d88a369087d1a8589943b2976f29c17625afcd14b282210c6202712ce887bdf7b01d6536d091c949f23ead4e6445f97706695e791489d0f22e92c554c48dc028555b12214412ac0eb105063a3932464b068649d499eea070eda0c57f0ba6b4f18d821c9242f40c01bc72f5b3abcc1ebeb30f25ca4209d177ee5d43574ba619a288c8a29410e15984d6354833dcd28995e0fd2eadb1e4e65307c606c2a911400566e1a4ec280d295a6d46c58fbcc2a629132a6527980a2a11b124cfae2e688b1616db91a637b5c58c6af04658b90d58091b2b70191e5ba3862f3914175caf43954528571781208ab786efa18538824bf7a8fc82dd0b8d48121360e7144bc3d0ad212055c28846745a0a6ae50ec889517e7960d1643445a1e295951cc36b54824cd284adf5a00955d8c7abcbd9b84a6ad6e03eba239af670c5b4c331447a819248eda1979c721ce04c21d249322eedd674be196eb32c40b0e4d544b5b2629338422f00dc3687a7a14b35639d99b3bd535831b34e07a31899884fbc93ec11a66b26f494217559e0696aa7640a2d4e79c4d6619fa599104c106206a36580a8808508758f03823efe25cb48e854225f030acf3a63214cf94b6279e1dd9a4f65b474a3ee85914372d03159ed2980b765ad6ec86a06e2b193b693011fe4ac20ba0604e7160c2e24c7229883c678f4df1f5018ae50a555f608a142ee49b0c327d07
          randwidth: 8000
        }
        {
          name: RndCnstBufferLfsrSeed
          desc: Compile-time random data for PRNG buffer default seed
          type: kmac_pkg::buffer_lfsr_seed_t
          randcount: 800
          randtype: data
          name_top: RndCnstKmacBufferLfsrSeed
          default: 0xf0c5de019fc073c4c599518bf1924441728893c652d7372432fcc4d3092bd6383fdba35279fcbcd2bd2c1319e71a293ac3249afc143e8770e304fee2d365da6c4a29010a99eaed073bcbd6e3eafa23f48eee34d31387b45b91ce49e4e6b587941d1eec35
          randwidth: 800
        }
        {
          name: RndCnstMsgPerm
          desc: Compile-time random permutation for LFSR Message output
          type: kmac_pkg::msg_perm_t
          randcount: 64
          randtype: perm
          name_top: RndCnstKmacMsgPerm
          default: 0xe63c8a4d623aa0734b5277b242db3e99f3133846457f3b55e89c7fb00327f91a112c1652c1f5b2af5ae4dedd052b89a
          randwidth: 384
        }
      ]
    }
    {
      name: keymgr
      type: keymgr
      base_addrs:
      {
        null:
        {
          hart: 0x41140000
        }
      }
      memory: {}
      param_list:
      [
        {
          name: RndCnstLfsrSeed
          desc: Compile-time random bits for initial LFSR seed
          type: keymgr_pkg::lfsr_seed_t
          randcount: 64
          randtype: data
          name_top: RndCnstKeymgrLfsrSeed
          default: 0x3335c20cc778fc30
          randwidth: 64
        }
        {
          name: RndCnstLfsrPerm
          desc: Compile-time random permutation for LFSR output
          type: keymgr_pkg::lfsr_perm_t
          randcount: 64
          randtype: perm
          name_top: RndCnstKeymgrLfsrPerm
          default: 0x59e4cef827c1e4c3444ab2bf029c15d681fd9d4b1ad21bf397a8f70f620992d3d16fc43b2d9c468187578b8a9ccae166
          randwidth: 384
        }
        {
          name: RndCnstRandPerm
          desc: Compile-time random permutation for entropy used in share overriding
          type: keymgr_pkg::rand_perm_t
          randcount: 32
          randtype: perm
          name_top: RndCnstKeymgrRandPerm
          default: 0x70b73c52df4492120fcb28151c9f55bf0cc7f5b0
          randwidth: 160
        }
        {
          name: RndCnstRevisionSeed
          desc: Compile-time random bits for revision seed
          type: keymgr_pkg::seed_t
          randcount: 256
          randtype: data
          name_top: RndCnstKeymgrRevisionSeed
          default: 0xd902019dabb6dd57022c77ede8609c409d905b3c7819b26a674328819928c5d7
          randwidth: 256
        }
        {
          name: RndCnstCreatorIdentitySeed
          desc: Compile-time random bits for creator identity seed
          type: keymgr_pkg::seed_t
          randcount: 256
          randtype: data
          name_top: RndCnstKeymgrCreatorIdentitySeed
          default: 0x9bf1db63d11e1c31bbc9a8c73fc4cc3d14ca6bc0b96812de7c775a54ff19343c
          randwidth: 256
        }
        {
          name: RndCnstOwnerIntIdentitySeed
          desc: Compile-time random bits for owner intermediate identity seed
          type: keymgr_pkg::seed_t
          randcount: 256
          randtype: data
          name_top: RndCnstKeymgrOwnerIntIdentitySeed
          default: 0xb32040b3490768889d27e0ba8588d34c05bcf127dae58b65d6a251088099b371
          randwidth: 256
        }
        {
          name: RndCnstOwnerIdentitySeed
          desc: Compile-time random bits for owner identity seed
          type: keymgr_pkg::seed_t
          randcount: 256
          randtype: data
          name_top: RndCnstKeymgrOwnerIdentitySeed
          default: 0x7b1cccf1a955f03de1a8447bf83b69c50e149cf51784a9d7ac691306e5c56ce
          randwidth: 256
        }
        {
          name: RndCnstSoftOutputSeed
          desc: Compile-time random bits for software generation seed
          type: keymgr_pkg::seed_t
          randcount: 256
          randtype: data
          name_top: RndCnstKeymgrSoftOutputSeed
          default: 0x38cd7d7e3b1abfb7978189a21ae856f1d908e3f70de343d2226e9e864465a8ee
          randwidth: 256
        }
        {
          name: RndCnstHardOutputSeed
          desc: Compile-time random bits for hardware generation seed
          type: keymgr_pkg::seed_t
          randcount: 256
          randtype: data
          name_top: RndCnstKeymgrHardOutputSeed
          default: 0x55ec0e6a296789ded5c0af59ee62f1fd1bbebeac2205b1fa5e94e72eb7eb1a71
          randwidth: 256
        }
        {
          name: RndCnstAesSeed
          desc: Compile-time random bits for generation seed when aes destination selected
          type: keymgr_pkg::seed_t
          randcount: 256
          randtype: data
          name_top: RndCnstKeymgrAesSeed
          default: 0x3ad15d2565d9ab4fbcd2e17c406f48d1401f8a6a52286f6954c27a9aefbe0bc9
          randwidth: 256
        }
        {
          name: RndCnstKmacSeed
          desc: Compile-time random bits for generation seed when kmac destination selected
          type: keymgr_pkg::seed_t
          randcount: 256
          randtype: data
          name_top: RndCnstKeymgrKmacSeed
          default: 0xee440c514ccacb019995f31fa958859293c5591ae604a92a303760eb8d7785a7
          randwidth: 256
        }
        {
          name: RndCnstAccSeed
          desc: Compile-time random bits for generation seed when acc destination selected
          type: keymgr_pkg::seed_t
          randcount: 256
          randtype: data
          name_top: RndCnstKeymgrAccSeed
          default: 0xbbdce1d6a02b6f0f24f5db8ef02f9fb0a4023d8f96a41f062bb66b228701e831
          randwidth: 256
        }
        {
          name: RndCnstCdi
          desc: Compile-time random bits for generation seed when no CDI is selected
          type: keymgr_pkg::seed_t
          randcount: 256
          randtype: data
          name_top: RndCnstKeymgrCdi
          default: 0x7cd4bf08bd6684a1d596cc57e137a0321fb803bfd2de7a90a1357e743ce46044
          randwidth: 256
        }
        {
          name: RndCnstNoneSeed
          desc: Compile-time random bits for generation seed when no destination selected
          type: keymgr_pkg::seed_t
          randcount: 256
          randtype: data
          name_top: RndCnstKeymgrNoneSeed
          default: 0x2c10686e82613de0806dde1d35ad6160ee7ef48222dad72d4d6289edd5f001dc
          randwidth: 256
        }
      ]
    }
    {
      name: csrng
      type: csrng
      base_addrs:
      {
        null:
        {
          hart: 0x41150000
        }
      }
      memory: {}
      param_list:
      [
        {
          name: RndCnstCsKeymgrDivNonProduction
          desc: Compile-time random bits for csrng state group diversification value
          type: csrng_pkg::cs_keymgr_div_t
          randcount: 384
          randtype: data
          name_top: RndCnstCsrngCsKeymgrDivNonProduction
          default: 0xd4095890a290a9b632f0395d11cac7f7e9e764add7ede232a4e00dabf1d1d2ad2e2a5133f6a12ff2ec1569bef1f0b924
          randwidth: 384
        }
        {
          name: RndCnstCsKeymgrDivProduction
          desc: Compile-time random bits for csrng state group diversification value
          type: csrng_pkg::cs_keymgr_div_t
          randcount: 384
          randtype: data
          name_top: RndCnstCsrngCsKeymgrDivProduction
          default: 0xc470ac5a99809985dc415ba1eaced382d54c9e378d030ea5d37665d43a035f4ea1e463032a3a8e24b4547f8b0db0c77e
          randwidth: 384
        }
      ]
    }
    {
      name: sram_ctrl_main
      type: sram_ctrl
      base_addrs:
      {
        regs:
        {
          hart: 0x411C0000
        }
        ram:
        {
          hart: 0x10000000
        }
      }
      memory:
      {
        ram:
        {
          label: ram_main
          swaccess: rw
          data_intg_passthru: True
          exec: True
          byte_write: True
          size: 0x20000
        }
      }
      param_list:
      [
        {
          name: RndCnstSramKey
          desc: Compile-time random reset value for SRAM scrambling key.
          type: otp_ctrl_pkg::sram_key_t
          randcount: 128
          randtype: data
          name_top: RndCnstSramCtrlMainSramKey
          default: 0x902776b104c3a9da02030621a4d3d738
          randwidth: 128
        }
        {
          name: RndCnstSramNonce
          desc: Compile-time random reset value for SRAM scrambling nonce.
          type: otp_ctrl_pkg::sram_nonce_t
          randcount: 128
          randtype: data
          name_top: RndCnstSramCtrlMainSramNonce
          default: 0x71fdaf5ad0c1dd1e95f99d7129ca6861
          randwidth: 128
        }
        {
          name: RndCnstLfsrSeed
          desc: Compile-time random bits for initial LFSR seed
          type: sram_ctrl_pkg::lfsr_seed_t
          randcount: 64
          randtype: data
          name_top: RndCnstSramCtrlMainLfsrSeed
          default: 0xa4425b9cc42edba8
          randwidth: 64
        }
        {
          name: RndCnstLfsrPerm
          desc: Compile-time random permutation for LFSR output
          type: sram_ctrl_pkg::lfsr_perm_t
          randcount: 64
          randtype: perm
          name_top: RndCnstSramCtrlMainLfsrPerm
          default: 0x6b87978462c36608c73d622ab25d09cf507fda8c50540f7b3ba73947eaca7c2c92353de96c475832fc249ae9fc52d162
          randwidth: 384
        }
      ]
    }
    {
      name: rom_ctrl
      type: rom_ctrl
      base_addrs:
      {
        rom:
        {
          hart: 0x00008000
        }
        regs:
        {
          hart: 0x411e0000
        }
      }
      memory:
      {
        rom:
        {
          label: rom
          swaccess: ro
          data_intg_passthru: True
          exec: True
          byte_write: False
          size: 0x8000
        }
      }
      param_list:
      [
        {
          name: RndCnstScrNonce
          desc: Fixed nonce used for address / data scrambling
          type: bit [63:0]
          randcount: 64
          randtype: data
          name_top: RndCnstRomCtrlScrNonce
          default: 0x44680ce93649a845
          randwidth: 64
        }
        {
          name: RndCnstScrKey
          desc: Randomised constant used as a scrambling key for ROM data
          type: bit [127:0]
          randcount: 128
          randtype: data
          name_top: RndCnstRomCtrlScrKey
          default: 0x75b465479f31a975234377e00d28ec32
          randwidth: 128
        }
      ]
    }
    {
      name: rv_core_ibex
      type: rv_core_ibex
      base_addrs:
      {
        cfg:
        {
          hart: 0x411F0000
        }
      }
      memory: {}
      param_list:
      [
        {
          name: RndCnstLfsrSeed
          desc: Default seed of the PRNG used for random instructions.
          type: ibex_pkg::lfsr_seed_t
          randcount: 32
          randtype: data
          name_top: RndCnstRvCoreIbexLfsrSeed
          default: 0xfa5850e8
          randwidth: 32
        }
        {
          name: RndCnstLfsrPerm
          desc: Permutation applied to the LFSR of the PRNG used for random instructions.
          type: ibex_pkg::lfsr_perm_t
          randcount: 32
          randtype: perm
          name_top: RndCnstRvCoreIbexLfsrPerm
          default: 0x67441359d7e0d6742a3b6e33093c89d54b3f83d4
          randwidth: 160
        }
        {
          name: RndCnstIbexKeyDefault
          desc: Default icache scrambling key
          type: logic [ibex_pkg::SCRAMBLE_KEY_W-1:0]
          randcount: 128
          randtype: data
          name_top: RndCnstRvCoreIbexIbexKeyDefault
          default: 0x1aad174dd41aca70d3807ba54e793023
          randwidth: 128
        }
        {
          name: RndCnstIbexNonceDefault
          desc: Default icache scrambling nonce
          type: logic [ibex_pkg::SCRAMBLE_NONCE_W-1:0]
          randcount: 64
          randtype: data
          name_top: RndCnstRvCoreIbexIbexNonceDefault
          default: 0xfa711994ccf5d2f4
          randwidth: 64
        }
      ]
      template_type: rv_core_ibex
    }
  ]
}
