// Copyright lowRISC contributors (OpenTitan project).
// Licensed under the Apache License, Version 2.0, see LICENSE for details.
// SPDX-License-Identifier: Apache-2.0
//
// ------------------- W A R N I N G: A U T O - G E N E R A T E D   C O D E !! -------------------//
// PLEASE DO NOT HAND-EDIT THIS FILE. IT HAS BEEN AUTO-GENERATED WITH THE FOLLOWING COMMAND:
// util/topgen.py -t hw/top_egret/data/top_egret.hjson
//                -o hw/top_egret/
{
  seed:
  {
    topgen_seed:
    {
      seed_mode: testing
      value: 1017106219537032642877583828875051302543807092889754935647094601236425074047
    }
    otp_img_seed:
    {
      seed_mode: testing
      value: 52408960416235844780753299194502148156786072650816676092165912261205302331741
    }
    lc_ctrl_seed:
    {
      seed_mode: testing
      value: 40182201019264397688411770949626922549663256047001778394918990008320537410392
    }
  }
  module:
  [
    {
      name: otp_ctrl
      type: otp_ctrl
      base_addrs:
      {
        core:
        {
          hart: 0x40130000
        }
      }
      memory: {}
      param_list:
      [
        {
          name: RndCnstLfsrSeed
          desc: Compile-time random bits for initial LFSR seed
          type: otp_ctrl_top_specific_pkg::lfsr_seed_t
          randcount: 40
          randtype: data
          name_top: RndCnstOtpCtrlLfsrSeed
          default: 0x57878a468d
          randwidth: 40
        }
        {
          name: RndCnstLfsrPerm
          desc: Compile-time random permutation for LFSR output
          type: otp_ctrl_top_specific_pkg::lfsr_perm_t
          randcount: 40
          randtype: perm
          name_top: RndCnstOtpCtrlLfsrPerm
          default: 0x9e045f2c259088949e61a9818c60178456c495c5073d94ca31d90d3950c8
          randwidth: 240
        }
        {
          name: RndCnstScrmblKeyInit
          desc: Compile-time random permutation for scrambling key/nonce register reset value
          type: otp_ctrl_top_specific_pkg::scrmbl_key_init_t
          randcount: 256
          randtype: data
          name_top: RndCnstOtpCtrlScrmblKeyInit
          default: 0x6759764645aad1fb21c18124635e3d50a88f6808045627ac18f377d9071beca6
          randwidth: 256
        }
        {
          name: RndCnstScrmblKey0
          desc: Compile-time scrambling key
          type: otp_ctrl_top_specific_pkg::key_t
          randcount: 128
          randtype: extdata
          name_top: RndCnstOtpCtrlScrmblKey0
          default: 0x8e023b1e052dac1e0fcebeac537edc
          randwidth: 128
        }
        {
          name: RndCnstScrmblKey1
          desc: Compile-time scrambling key
          type: otp_ctrl_top_specific_pkg::key_t
          randcount: 128
          randtype: extdata
          name_top: RndCnstOtpCtrlScrmblKey1
          default: 0x7848da13345040c295fcbd76684e7170
          randwidth: 128
        }
        {
          name: RndCnstScrmblKey2
          desc: Compile-time scrambling key
          type: otp_ctrl_top_specific_pkg::key_t
          randcount: 128
          randtype: extdata
          name_top: RndCnstOtpCtrlScrmblKey2
          default: 0x57af03288e6c3c383a73e698950bfab6
          randwidth: 128
        }
        {
          name: RndCnstScrmblKey3
          desc: Compile-time scrambling key
          type: otp_ctrl_top_specific_pkg::key_t
          randcount: 128
          randtype: extdata
          name_top: RndCnstOtpCtrlScrmblKey3
          default: 0x9acf416ad5455d1dea1ea059dc5c584c
          randwidth: 128
        }
        {
          name: RndCnstDigestConst0
          desc: Compile-time digest const
          type: otp_ctrl_top_specific_pkg::digest_const_t
          randcount: 128
          randtype: extdata
          name_top: RndCnstOtpCtrlDigestConst0
          default: 0x74e7b5c15957663ac0a5a56f968fd7e9
          randwidth: 128
        }
        {
          name: RndCnstDigestConst1
          desc: Compile-time digest const
          type: otp_ctrl_top_specific_pkg::digest_const_t
          randcount: 128
          randtype: extdata
          name_top: RndCnstOtpCtrlDigestConst1
          default: 0x7a827e95a7385b32c02abd645fc814bc
          randwidth: 128
        }
        {
          name: RndCnstDigestConst2
          desc: Compile-time digest const
          type: otp_ctrl_top_specific_pkg::digest_const_t
          randcount: 128
          randtype: extdata
          name_top: RndCnstOtpCtrlDigestConst2
          default: 0xfe6728d0d0879ec62214d76208e9943a
          randwidth: 128
        }
        {
          name: RndCnstDigestConst3
          desc: Compile-time digest const
          type: otp_ctrl_top_specific_pkg::digest_const_t
          randcount: 128
          randtype: extdata
          name_top: RndCnstOtpCtrlDigestConst3
          default: 0xe17e956c21b003d0bcb1cbcd1eb02317
          randwidth: 128
        }
        {
          name: RndCnstDigestIV0
          desc: Compile-time digest initial vector
          type: otp_ctrl_top_specific_pkg::digest_iv_t
          randcount: 64
          randtype: extdata
          name_top: RndCnstOtpCtrlDigestIV0
          default: 0x99e3e946397824f3
          randwidth: 64
        }
        {
          name: RndCnstDigestIV1
          desc: Compile-time digest initial vector
          type: otp_ctrl_top_specific_pkg::digest_iv_t
          randcount: 64
          randtype: extdata
          name_top: RndCnstOtpCtrlDigestIV1
          default: 0x8071ef1bff0c99f0
          randwidth: 64
        }
        {
          name: RndCnstDigestIV2
          desc: Compile-time digest initial vector
          type: otp_ctrl_top_specific_pkg::digest_iv_t
          randcount: 64
          randtype: extdata
          name_top: RndCnstOtpCtrlDigestIV2
          default: 0xbc1cfcff9f3e4cd4
          randwidth: 64
        }
        {
          name: RndCnstDigestIV3
          desc: Compile-time digest initial vector
          type: otp_ctrl_top_specific_pkg::digest_iv_t
          randcount: 64
          randtype: extdata
          name_top: RndCnstOtpCtrlDigestIV3
          default: 0x43242540d2120889
          randwidth: 64
        }
        {
          name: RndCnstPartInvDefault
          desc: OTP invalid partition default for buffered partitions
          type: logic [32767:0]
          randcount: 32768
          randtype: extdata
          name_top: RndCnstOtpCtrlPartInvDefault
          default:
          [
            {
              size: 704
              items:
              [
                {
                  size: 320
                  inv_default: 150724158863578290761376796642879324047970044817803993230695865344826642621771004974996689303386
                }
                {
                  size: 384
                  inv_default: 6707296131048348035660209850454458516403716907741954216822891807334833183171263528798563328586680206667318424192181
                }
              ]
            }
            {
              size: 384
              items:
              [
                {
                  size: 64
                  inv_default: 0
                }
                {
                  size: 64
                  inv_default: 10535273937158094
                }
                {
                  size: 256
                  inv_default: 46917961507141145256060626454085849401363337700765221407992884200406625985337
                }
              ]
            }
            {
              size: 960
              items:
              [
                {
                  size: 64
                  inv_default: 14536313462089013680
                }
                {
                  size: 256
                  inv_default: 42840131334136411941200644947425579008419079534194068434596656023607238656790
                }
                {
                  size: 256
                  inv_default: 33599205987092681210239649990958622833804933314610392317109421837165274603539
                }
                {
                  size: 256
                  inv_default: 92348881548169349828605117641018822276568973017337749653532230513078504803567
                }
                {
                  size: 128
                  inv_default: 130971651290035026448304299560793978178
                }
              ]
            }
            {
              size: 704
              items:
              [
                {
                  size: 64
                  inv_default: 16098215510217229036
                }
                {
                  size: 128
                  inv_default: 334671433878751700697199779069205613746
                }
                {
                  size: 256
                  inv_default: 7536910898370239450524093328085871963862640062161248607096610222518662706945
                }
                {
                  size: 256
                  inv_default: 23531955425096136348941735642650773479001928178605645757494297030518339325231
                }
              ]
            }
            {
              size: 320
              items:
              [
                {
                  size: 64
                  inv_default: 15449436981428020477
                }
                {
                  size: 128
                  inv_default: 335469059873213918850882942343750995942
                }
                {
                  size: 128
                  inv_default: 230748029623541578864187550162391519735
                }
              ]
            }
            {
              size: 384
              items:
              [
                {
                  size: 64
                  inv_default: 0
                }
                {
                  size: 64
                  inv_default: 354744590412343289
                }
                {
                  size: 256
                  inv_default: 74703898927885615228644073031729127987260023218980427977577683364343954231749
                }
              ]
            }
            {
              size: 128
              items:
              [
                {
                  size: 64
                  inv_default: 13961193720981549769
                }
                {
                  comment: unallocated space
                  size: 40
                  inv_default: 0
                }
                {
                  size: 8
                  inv_default: 105
                }
                {
                  size: 8
                  inv_default: 105
                }
                {
                  size: 8
                  inv_default: 105
                }
              ]
            }
            {
              size: 320
              items:
              [
                {
                  size: 64
                  inv_default: 12018756830038280371
                }
                {
                  size: 256
                  inv_default: 75416344968344595199184561357653563771667887286318218849004063607029244022168
                }
              ]
            }
            {
              size: 640
              items:
              [
                {
                  size: 64
                  inv_default: 0
                }
                {
                  size: 576
                  inv_default: 0
                }
              ]
            }
            {
              size: 64
              items:
              [
                {
                  size: 64
                  inv_default: 7532579203220097263
                }
              ]
            }
            {
              size: 64
              items:
              [
                {
                  size: 64
                  inv_default: 6748737775371490481
                }
              ]
            }
            {
              size: 128
              items:
              [
                {
                  size: 64
                  inv_default: 0
                }
                {
                  size: 64
                  inv_default: 16239032379200962209
                }
              ]
            }
            {
              size: 8256
              items:
              [
                {
                  size: 64
                  inv_default: 0
                }
                {
                  size: 8192
                  inv_default: 0
                }
              ]
            }
            {
              size: 128
              items:
              [
                {
                  size: 64
                  inv_default: 16772361003296535520
                }
                {
                  size: 32
                  inv_default: 0
                }
                {
                  size: 32
                  inv_default: 0
                }
              ]
            }
            {
              size: 128
              items:
              [
                {
                  size: 64
                  inv_default: 5776996463561863949
                }
                {
                  size: 32
                  inv_default: 0
                }
                {
                  size: 32
                  inv_default: 0
                }
              ]
            }
            {
              size: 192
              items:
              [
                {
                  size: 64
                  inv_default: 17765946314086229411
                }
                {
                  size: 32
                  inv_default: 0
                }
                {
                  size: 32
                  inv_default: 0
                }
                {
                  size: 32
                  inv_default: 0
                }
                {
                  size: 32
                  inv_default: 0
                }
              ]
            }
            {
              size: 192
              items:
              [
                {
                  size: 64
                  inv_default: 18410855119173665658
                }
                {
                  size: 32
                  inv_default: 0
                }
                {
                  size: 32
                  inv_default: 0
                }
                {
                  size: 32
                  inv_default: 0
                }
                {
                  size: 32
                  inv_default: 0
                }
              ]
            }
            {
              size: 960
              items:
              [
                {
                  size: 64
                  inv_default: 0
                }
                {
                  size: 64
                  inv_default: 5835184937972759951
                }
                {
                  size: 32
                  inv_default: 0
                }
                {
                  size: 256
                  inv_default: 0
                }
                {
                  size: 512
                  inv_default: 0
                }
                {
                  size: 32
                  inv_default: 0
                }
              ]
            }
            {
              size: 960
              items:
              [
                {
                  size: 64
                  inv_default: 0
                }
                {
                  size: 64
                  inv_default: 13248414165649443033
                }
                {
                  size: 32
                  inv_default: 0
                }
                {
                  size: 256
                  inv_default: 0
                }
                {
                  size: 512
                  inv_default: 0
                }
                {
                  size: 32
                  inv_default: 0
                }
              ]
            }
            {
              size: 960
              items:
              [
                {
                  size: 64
                  inv_default: 0
                }
                {
                  size: 64
                  inv_default: 17787990554517712170
                }
                {
                  size: 32
                  inv_default: 0
                }
                {
                  size: 256
                  inv_default: 0
                }
                {
                  size: 512
                  inv_default: 0
                }
                {
                  size: 32
                  inv_default: 0
                }
              ]
            }
            {
              size: 960
              items:
              [
                {
                  size: 64
                  inv_default: 0
                }
                {
                  size: 64
                  inv_default: 17014664945089674915
                }
                {
                  size: 32
                  inv_default: 0
                }
                {
                  size: 256
                  inv_default: 0
                }
                {
                  size: 512
                  inv_default: 0
                }
                {
                  size: 32
                  inv_default: 0
                }
              ]
            }
            {
              size: 6400
              items:
              [
                {
                  size: 64
                  inv_default: 0
                }
                {
                  size: 64
                  inv_default: 7388996329285901817
                }
                {
                  size: 128
                  inv_default: 0
                }
                {
                  size: 6144
                  inv_default: 0
                }
              ]
            }
            {
              size: 64
              items:
              [
                {
                  size: 64
                  inv_default: 0
                }
              ]
            }
            {
              size: 5120
              items:
              [
                {
                  size: 64
                  inv_default: 18239385572812637686
                }
                {
                  comment: unallocated space
                  size: 672
                  inv_default: 0
                }
                {
                  size: 32
                  inv_default: 0
                }
                {
                  size: 32
                  inv_default: 0
                }
                {
                  size: 96
                  inv_default: 0
                }
                {
                  size: 32
                  inv_default: 0
                }
                {
                  size: 32
                  inv_default: 0
                }
                {
                  size: 32
                  inv_default: 0
                }
                {
                  size: 32
                  inv_default: 0
                }
                {
                  size: 32
                  inv_default: 0
                }
                {
                  size: 32
                  inv_default: 0
                }
                {
                  size: 32
                  inv_default: 0
                }
                {
                  size: 32
                  inv_default: 0
                }
                {
                  size: 512
                  inv_default: 0
                }
                {
                  size: 128
                  inv_default: 0
                }
                {
                  size: 128
                  inv_default: 0
                }
                {
                  size: 512
                  inv_default: 0
                }
                {
                  size: 2560
                  inv_default: 0
                }
                {
                  size: 32
                  inv_default: 0
                }
                {
                  size: 32
                  inv_default: 0
                }
                {
                  size: 32
                  inv_default: 0
                }
                {
                  size: 32
                  inv_default: 0
                }
              ]
            }
            {
              size: 3136
              items:
              [
                {
                  size: 64
                  inv_default: 1763780682035308140
                }
                {
                  comment: unallocated space
                  size: 672
                  inv_default: 0
                }
                {
                  size: 256
                  inv_default: 0
                }
                {
                  size: 32
                  inv_default: 0
                }
                {
                  size: 32
                  inv_default: 0
                }
                {
                  size: 32
                  inv_default: 0
                }
                {
                  size: 32
                  inv_default: 0
                }
                {
                  size: 32
                  inv_default: 0
                }
                {
                  size: 32
                  inv_default: 0
                }
                {
                  size: 32
                  inv_default: 0
                }
                {
                  size: 32
                  inv_default: 0
                }
                {
                  size: 32
                  inv_default: 0
                }
                {
                  size: 32
                  inv_default: 0
                }
                {
                  size: 32
                  inv_default: 0
                }
                {
                  size: 32
                  inv_default: 0
                }
                {
                  size: 32
                  inv_default: 0
                }
                {
                  size: 32
                  inv_default: 0
                }
                {
                  size: 32
                  inv_default: 0
                }
                {
                  size: 32
                  inv_default: 0
                }
                {
                  size: 32
                  inv_default: 0
                }
                {
                  size: 32
                  inv_default: 0
                }
                {
                  size: 32
                  inv_default: 0
                }
                {
                  size: 32
                  inv_default: 0
                }
                {
                  size: 32
                  inv_default: 0
                }
                {
                  size: 32
                  inv_default: 0
                }
                {
                  size: 32
                  inv_default: 0
                }
                {
                  size: 32
                  inv_default: 0
                }
                {
                  size: 32
                  inv_default: 0
                }
                {
                  size: 32
                  inv_default: 0
                }
                {
                  size: 32
                  inv_default: 0
                }
                {
                  size: 32
                  inv_default: 0
                }
                {
                  size: 1248
                  inv_default: 0
                }
              ]
            }
            {
              size: 512
              items:
              [
                {
                  size: 64
                  inv_default: 10376061010840826049
                }
                {
                  size: 448
                  inv_default: 0
                }
              ]
            }
          ]
          randwidth: 32768
        }
      ]
      template_type: otp_ctrl
      otp_mmap:
      {
        otp:
        {
          width: 2
          depth: 2048
          size: 4096
          addr_width: 11
          byte_addr_width: 12
        }
        scrambling:
        {
          key_size: 16
          iv_size: 8
          cnst_size: 16
          keys:
          [
            {
              name: Secret0Key
              value: 737351402483551773424408676158111452
            }
            {
              name: Secret1Key
              value: 159885627954823336570095967134108512624
            }
            {
              name: Secret2Key
              value: 116551551643964307065576810321281809078
            }
            {
              name: Secret3Key
              value: 205777243621407380322297933138314942540
            }
          ]
          digests:
          [
            {
              name: CnstyDigest
              iv_value: 11088963195337450739
              cnst_value: 155393554520195237829976329809831122921
            }
            {
              name: FlashDataKey
              iv_value: 9255441612745251312
              cnst_value: 162843381517727665979430423445830636732
            }
            {
              name: FlashAddrKey
              iv_value: 13554987153296870612
              cnst_value: 338159545346176504814408005524965135418
            }
            {
              name: SramDataKey
              iv_value: 4838032860035287177
              cnst_value: 299733559101879749609968710118787785495
            }
          ]
          num_keys: 4
          num_digests: 4
        }
        partitions:
        [
          {
            name: VENDOR_TEST
            variant: Unbuffered
            secret: false
            sw_digest: true
            hw_digest: false
            write_lock: Digest
            read_lock: CSR
            key_sel: NoKey
            integrity: false
            bkout_type: false
            skip_sw_header: true
            items:
            [
              {
                name: SCRATCH
                size: 56
                isdigest: false
                iszer: false
                ismubi: false
                iskeymgr_creator: false
                iskeymgr_owner: false
                absorb: false
                inv_default: 0
                offset: 0
              }
              {
                name: VENDOR_TEST_DIGEST
                size: 8
                offset: 56
                ismubi: false
                isdigest: true
                iszer: false
                inv_default: 10376061010840826049
                iskeymgr_creator: false
                iskeymgr_owner: false
              }
            ]
            desc:
              '''
              Vendor test partition.
              This is reserved for manufacturing smoke checks. The OTP wrapper
              control logic inside otp_macro is allowed to read/write to this
              region. ECC uncorrectable errors seen on the functional otp_macro
              interface will not lead to an alert for this partition.
              Instead, such errors will be reported as correctable ECC errors.
              '''
            absorb: false
            iskeymgr_creator: false
            iskeymgr_owner: false
            zeroizable: false
            ignore_read_lock_in_rma: false
            size: 64
            offset: 0
          }
          {
            name: CREATOR_SW_CFG
            variant: Unbuffered
            absorb: true
            secret: false
            sw_digest: true
            hw_digest: false
            write_lock: Digest
            read_lock: CSR
            key_sel: NoKey
            integrity: true
            bkout_type: false
            items:
            [
              {
                name: CREATOR_SW_CFG_AST_CFG
                size: 156
                desc:
                  '''
                  AST configuration data. These values get blindly copied to
                  the AST CSRs during ROM execution.
                  '''
                isdigest: false
                iszer: false
                ismubi: false
                iskeymgr_creator: false
                iskeymgr_owner: false
                absorb: false
                inv_default: 0
                offset: 64
              }
              {
                name: CREATOR_SW_CFG_AST_INIT_SIZE
                size: 4
                desc:
                  '''
                  Controls how many 32-bit words from the CREATOR_SW_CFG_AST_CFG item
                  get copied to the AST CSRs during ROM execution.
                  '''
                isdigest: false
                iszer: false
                ismubi: false
                iskeymgr_creator: false
                iskeymgr_owner: false
                absorb: false
                inv_default: 0
                offset: 220
              }
              {
                name: CREATOR_SW_CFG_SIGVERIFY_SPX_EN
                size: 4
                desc:
                  '''
                  Controls whether or not SPHINCS+ signature verification will
                  be executed when the ROM attempts to boot the ROM_EXT.
                  A value of kSigverifySpxDisabledOtp disables SPHINCS+
                  signature verification, while all other values enable it.
                  '''
                isdigest: false
                iszer: false
                ismubi: false
                iskeymgr_creator: false
                iskeymgr_owner: false
                absorb: false
                inv_default: 0
                offset: 224
              }
              {
                name: CREATOR_SW_CFG_FLASH_DATA_DEFAULT_CFG
                size: 4
                desc:
                  '''
                  The default scrambling, ECC, and high endurance
                  configuration settings for flash data pages set during ROM
                  execution.
                  '''
                isdigest: false
                iszer: false
                ismubi: false
                iskeymgr_creator: false
                iskeymgr_owner: false
                absorb: false
                inv_default: 0
                offset: 228
              }
              {
                name: CREATOR_SW_CFG_FLASH_INFO_BOOT_DATA_CFG
                size: 4
                desc:
                  '''
                  The scrambling, ECC, and high endurance configuration
                  settings for the boot data flash info pages set during ROM
                  execution.
                  '''
                isdigest: false
                iszer: false
                ismubi: false
                iskeymgr_creator: false
                iskeymgr_owner: false
                absorb: false
                inv_default: 0
                offset: 232
              }
              {
                name: CREATOR_SW_CFG_FLASH_HW_INFO_CFG_OVERRIDE
                size: 4
                desc:
                  '''
                  Scrambling and ECC configuration overrides (set by the ROM)
                  for the Creator and OwnerSeed flash info pages (pages 1 and
                  2 in partition 0) that are hardwired to the keygmr. By
                  default, scrambling and ECC on these flash info pages must
                  be enabled in order to successfully crank the keygmr (in the
                  ROM_EXT). However, values of kMultiBitBool4True for each
                  subfield in this field will disable this requirement. See
                  the HW_INFO_CFG_OVERRIDE flash_ctrl CSR for more details.
                  '''
                isdigest: false
                iszer: false
                ismubi: false
                iskeymgr_creator: false
                iskeymgr_owner: false
                absorb: false
                inv_default: 0
                offset: 236
              }
              {
                name: CREATOR_SW_CFG_RNG_EN
                size: 4
                desc:
                  '''
                  Whether or not to enable use of hardware generated entropy
                  (from the entropy complex via EDN) in the `rnd_uint32`
                  function. A value of kHardenedBoolTrue enables the use of
                  hardware generated entropy, while all other values disable.
                  '''
                isdigest: false
                iszer: false
                ismubi: false
                iskeymgr_creator: false
                iskeymgr_owner: false
                absorb: false
                inv_default: 0
                offset: 240
              }
              {
                name: CREATOR_SW_CFG_JITTER_EN
                size: 4
                desc:
                  '''
                  Whether or not to enable clock jitter. A value of
                  kMultiBitBool4False disables, while all other values enable.
                  '''
                isdigest: false
                iszer: false
                ismubi: false
                iskeymgr_creator: false
                iskeymgr_owner: false
                absorb: false
                inv_default: 0
                offset: 244
              }
              {
                name: CREATOR_SW_CFG_RET_RAM_RESET_MASK
                size: 4
                desc:
                  '''
                  Reset reason mask used to initialize (by overwriting with
                  random data) retention SRAM during ROM execution. A value of
                  0 only initializes retention SRAM on power-on-resets.See
                  rstmgr RESET_INFO CSR documentation for more details.
                  '''
                isdigest: false
                iszer: false
                ismubi: false
                iskeymgr_creator: false
                iskeymgr_owner: false
                absorb: false
                inv_default: 0
                offset: 248
              }
              {
                name: CREATOR_SW_CFG_MANUF_STATE
                size: 4
                desc:
                  '''
                  Manufacturing state binding field. For use by
                  SiliconCreators or SiliconOwners to bind ROM_EXT images to a
                  specific device or set of devices.
                  '''
                isdigest: false
                iszer: false
                ismubi: false
                iskeymgr_creator: false
                iskeymgr_owner: false
                absorb: false
                inv_default: 0
                offset: 252
              }
              {
                name: CREATOR_SW_CFG_ROM_EXEC_EN
                size: 4
                desc:
                  '''
                  Whether or not to enable execution of ROM. A value of 0
                  disables, while all other values enable. This enables
                  provisioning flows to attach JTAG connections and halt the
                  CPU before the device has been fully provisioned. All SKUs
                  should set this field to a non-zero value. Provisioning
                  flows shall take care to program this field at the
                  appropriate time during.
                  '''
                isdigest: false
                iszer: false
                ismubi: false
                iskeymgr_creator: false
                iskeymgr_owner: false
                absorb: false
                inv_default: 0
                offset: 256
              }
              {
                name: CREATOR_SW_CFG_CPUCTRL
                size: 4
                desc:
                  '''
                  Value to write to the Ibex CPUCTRL CSR during ROM execution.
                  This field controls settings such as ICACHE enablement. See
                  Ibex documentation for more information.
                  '''
                isdigest: false
                iszer: false
                ismubi: false
                iskeymgr_creator: false
                iskeymgr_owner: false
                absorb: false
                inv_default: 0
                offset: 260
              }
              {
                name: CREATOR_SW_CFG_MIN_SEC_VER_ROM_EXT
                size: 4
                desc:
                  '''
                  Value of the min_security_version_rom_ext field of the
                  default boot data.
                  '''
                isdigest: false
                iszer: false
                ismubi: false
                iskeymgr_creator: false
                iskeymgr_owner: false
                absorb: false
                inv_default: 0
                offset: 264
              }
              {
                name: CREATOR_SW_CFG_MIN_SEC_VER_BL0
                size: 4
                desc:
                  '''
                  Value of the min_security_version_bl0 field of the
                  default boot data.
                  '''
                isdigest: false
                iszer: false
                ismubi: false
                iskeymgr_creator: false
                iskeymgr_owner: false
                absorb: false
                inv_default: 0
                offset: 268
              }
              {
                name: CREATOR_SW_CFG_RNG_REPCNT_THRESHOLDS
                size: 4
                desc:
                  '''
                  The repetition count health test thresholds to enable
                  entropy_src with during ROM execution.
                  This must be configured if CREATOR_SW_CFG_RNG_EN is true.
                  See entropy_src documentation for more details.
                  '''
                isdigest: false
                iszer: false
                ismubi: false
                iskeymgr_creator: false
                iskeymgr_owner: false
                absorb: false
                inv_default: 0
                offset: 272
              }
              {
                name: CREATOR_SW_CFG_RNG_REPCNTS_THRESHOLDS
                size: 4
                desc:
                  '''
                  The repetition count symbol health test thresholds to enable
                  entropy_src with during ROM execution.
                  This must be configured if CREATOR_SW_CFG_RNG_EN is true.
                  See entropy_src documentation for more details.
                  '''
                isdigest: false
                iszer: false
                ismubi: false
                iskeymgr_creator: false
                iskeymgr_owner: false
                absorb: false
                inv_default: 0
                offset: 276
              }
              {
                name: CREATOR_SW_CFG_RNG_ADAPTP_HI_THRESHOLDS
                size: 4
                desc:
                  '''
                  The adaptive proportion health test high thresholds to
                  enable entropy_src with during ROM execution.
                  This must be configured if CREATOR_SW_CFG_RNG_EN is true.
                  See entropy_src documentation for more details.
                  '''
                isdigest: false
                iszer: false
                ismubi: false
                iskeymgr_creator: false
                iskeymgr_owner: false
                absorb: false
                inv_default: 0
                offset: 280
              }
              {
                name: CREATOR_SW_CFG_RNG_ADAPTP_LO_THRESHOLDS
                size: 4
                desc:
                  '''
                  The adaptive proportion health test low thresholds to enable
                  entropy_src with during ROM execution.
                  This must be configured if CREATOR_SW_CFG_RNG_EN is true.
                  See entropy_src documentation for more details.
                  '''
                isdigest: false
                iszer: false
                ismubi: false
                iskeymgr_creator: false
                iskeymgr_owner: false
                absorb: false
                inv_default: 0
                offset: 284
              }
              {
                name: CREATOR_SW_CFG_RNG_BUCKET_THRESHOLDS
                size: 4
                desc:
                  '''
                  The bucket health test thresholds to enable entropy_src with
                  during ROM execution.
                  This must be configured if CREATOR_SW_CFG_RNG_EN is true.
                  See entropy_src documentation for more details.
                  '''
                isdigest: false
                iszer: false
                ismubi: false
                iskeymgr_creator: false
                iskeymgr_owner: false
                absorb: false
                inv_default: 0
                offset: 288
              }
              {
                name: CREATOR_SW_CFG_RNG_MARKOV_HI_THRESHOLDS
                size: 4
                desc:
                  '''
                  The Markov health test high thresholds to enable entropy_src
                  with during ROM execution.
                  This must be configured if CREATOR_SW_CFG_RNG_EN is true.
                  See entropy_src documentation for more details.
                  '''
                isdigest: false
                iszer: false
                ismubi: false
                iskeymgr_creator: false
                iskeymgr_owner: false
                absorb: false
                inv_default: 0
                offset: 292
              }
              {
                name: CREATOR_SW_CFG_RNG_MARKOV_LO_THRESHOLDS
                size: 4
                desc:
                  '''
                  The Markov health test low thresholds to enable entropy_src
                  with during ROM execution.
                  This must be configured if CREATOR_SW_CFG_RNG_EN is true.
                  See entropy_src documentation for more details.
                  '''
                isdigest: false
                iszer: false
                ismubi: false
                iskeymgr_creator: false
                iskeymgr_owner: false
                absorb: false
                inv_default: 0
                offset: 296
              }
              {
                name: CREATOR_SW_CFG_RNG_EXTHT_HI_THRESHOLDS
                size: 4
                desc:
                  '''
                  The external health test high thresholds to enable the
                  entropy_src with during ROM execution.
                  This must be configured if CREATOR_SW_CFG_RNG_EN is true.
                  See entropy_src documentation for more details.
                  '''
                isdigest: false
                iszer: false
                ismubi: false
                iskeymgr_creator: false
                iskeymgr_owner: false
                absorb: false
                inv_default: 0
                offset: 300
              }
              {
                name: CREATOR_SW_CFG_RNG_EXTHT_LO_THRESHOLDS
                size: 4
                desc:
                  '''
                  The external health test low thresholds to enable the
                  entropy_src with during ROM execution.
                  This must be configured if CREATOR_SW_CFG_RNG_EN is true.
                  See entropy_src documentation for more details.
                  '''
                isdigest: false
                iszer: false
                ismubi: false
                iskeymgr_creator: false
                iskeymgr_owner: false
                absorb: false
                inv_default: 0
                offset: 304
              }
              {
                name: CREATOR_SW_CFG_RNG_ALERT_THRESHOLD
                size: 4
                desc:
                  '''
                  The alert threshold to configure the entropy_src with during
                  ROM execution.
                  This must be configured if CREATOR_SW_CFG_RNG_EN is true.
                  See entropy_src documentation for more details.
                  '''
                isdigest: false
                iszer: false
                ismubi: false
                iskeymgr_creator: false
                iskeymgr_owner: false
                absorb: false
                inv_default: 0
                offset: 308
              }
              {
                name: CREATOR_SW_CFG_RNG_HEALTH_CONFIG_DIGEST
                size: 4
                desc:
                  '''
                  A CRC32 digest of all entropy_src health test threshold
                  configuration fields above.
                  This must be configured if CREATOR_SW_CFG_RNG_EN is true.
                  See entropy_src documentation for more details.
                  '''
                isdigest: false
                iszer: false
                ismubi: false
                iskeymgr_creator: false
                iskeymgr_owner: false
                absorb: false
                inv_default: 0
                offset: 312
              }
              {
                name: CREATOR_SW_CFG_SRAM_KEY_RENEW_AND_INIT_EN
                size: 4
                desc:
                  '''
                  Whether or not the ROM should request SRAM to be rescrambled
                  with a new key on every boot. This includes renewing the
                  scrambling key and then initializing SRAM with pseudo-random
                  data. kHardenedBoolFalse disables, while all other values
                  enable.
                  '''
                isdigest: false
                iszer: false
                ismubi: false
                iskeymgr_creator: false
                iskeymgr_owner: false
                absorb: false
                inv_default: 0
                offset: 316
              }
              {
                name: CREATOR_SW_CFG_IMMUTABLE_ROM_EXT_EN
                size: 4
                desc:
                  '''
                  Enablement of the ROM_EXT immutable code section.
                  A value of kHardenedBoolTrue enables the feature.
                  All other values disable it.
                  '''
                isdigest: false
                iszer: false
                ismubi: false
                iskeymgr_creator: false
                iskeymgr_owner: false
                absorb: false
                inv_default: 0
                offset: 320
              }
              {
                name: CREATOR_SW_CFG_IMMUTABLE_ROM_EXT_START_OFFSET
                size: 4
                desc:
                  '''
                  Relative offset from the start of the ROM_EXT slot to
                  find the immutable code section at.
                  '''
                isdigest: false
                iszer: false
                ismubi: false
                iskeymgr_creator: false
                iskeymgr_owner: false
                absorb: false
                inv_default: 0
                offset: 324
              }
              {
                name: CREATOR_SW_CFG_IMMUTABLE_ROM_EXT_LENGTH
                size: 4
                desc: Length (in bytes) of the immutable code section.
                isdigest: false
                iszer: false
                ismubi: false
                iskeymgr_creator: false
                iskeymgr_owner: false
                absorb: false
                inv_default: 0
                offset: 328
              }
              {
                name: CREATOR_SW_CFG_IMMUTABLE_ROM_EXT_SHA256_HASH
                size: 32
                desc: SHA256 hash of the immutable ROM_EXT section.
                isdigest: false
                iszer: false
                ismubi: false
                iskeymgr_creator: false
                iskeymgr_owner: false
                absorb: false
                inv_default: 0
                offset: 332
              }
              {
                name: CREATOR_SW_CFG_DIGEST
                size: 8
                offset: 448
                ismubi: false
                isdigest: true
                iszer: false
                inv_default: 1763780682035308140
                iskeymgr_creator: false
                iskeymgr_owner: false
              }
            ]
            desc:
              '''
              Software configuration partition.
              This is for device-specific calibration data, e.g, clock, LDO, RNG,
              and configuration settings set by the ROM.
              '''
            iskeymgr_creator: false
            iskeymgr_owner: false
            zeroizable: false
            ignore_read_lock_in_rma: false
            size: 392
            offset: 64
          }
          {
            name: OWNER_SW_CFG
            variant: Unbuffered
            absorb: true
            secret: false
            sw_digest: true
            hw_digest: false
            write_lock: Digest
            read_lock: CSR
            key_sel: NoKey
            integrity: true
            bkout_type: false
            items:
            [
              {
                name: OWNER_SW_CFG_ROM_ERROR_REPORTING
                size: 4
                desc:
                  '''
                  The shutdown error reporting verbosity used by the ROM.
                  Should be configured to one of several
                  `shutdown_error_redact_t` values. See
                  `sw/device/silicon_creator/lib/shutdown.h` for more details.
                  '''
                isdigest: false
                iszer: false
                ismubi: false
                iskeymgr_creator: false
                iskeymgr_owner: false
                absorb: false
                inv_default: 0
                offset: 456
              }
              {
                name: OWNER_SW_CFG_ROM_BOOTSTRAP_DIS
                size: 4
                desc:
                  '''
                  Whether or not to disable ROM bootstrap mechanism. A value
                  of kHardenedBoolTrue disable bootstrap mechanism in the ROM,
                  while all other values enable it. Note, the provisioning
                  flow should take care when to program this field if it is
                  used by a SKU, as there is no way to get firmware into flash
                  in a PROD LC state if a valid ROM_EXT does not already exist
                  in flash once this value is configured to true.
                  '''
                isdigest: false
                iszer: false
                ismubi: false
                iskeymgr_creator: false
                iskeymgr_owner: false
                absorb: false
                inv_default: 0
                offset: 460
              }
              {
                name: OWNER_SW_CFG_ROM_ALERT_CLASS_EN
                size: 4
                desc:
                  '''
                  A four byte packed field, where each byte controls whether
                  or not the ROM enables each alert class (A through D) of the
                  alert_handler. The byte-sized subfields are arranged from D
                  to A, MSB to LSB. Each byte should be set to an
                  `alert_enable_t` value accordingly. See the alert_handler
                  documentation for more details.
                  '''
                isdigest: false
                iszer: false
                ismubi: false
                iskeymgr_creator: false
                iskeymgr_owner: false
                absorb: false
                inv_default: 0
                offset: 464
              }
              {
                name: OWNER_SW_CFG_ROM_ALERT_ESCALATION
                size: 4
                desc:
                  '''
                  A four byte packed field, where each byte controls the
                  escalation configuration for each alert class (A through D)
                  of the alert_handler configured by the ROM. The byte-sized
                  subfields are arranged from D to A, MSB to LSB. Each byte
                  should be set to an `alert_escalate_t` value accordingly.
                  See the alert_handler documentation for more details.
                  '''
                isdigest: false
                iszer: false
                ismubi: false
                iskeymgr_creator: false
                iskeymgr_owner: false
                absorb: false
                inv_default: 0
                offset: 468
              }
              {
                name: OWNER_SW_CFG_ROM_ALERT_CLASSIFICATION
                size: 320
                desc:
                  '''
                  The alert classifications (A through D) for each alert
                  source of the alert_handler to be configured by the ROM. The
                  field consists of a contiguous 320-byte block, or 80 32-bit
                  words. The four bytes in each word encode the configuration
                  of a single alert source across four lifecycle states, in
                  order from LSB to MSB: PROD, PROD_END, DEV, and RMA. Each
                  byte should be set to an `alert_class_t` value accordingly.
                  The order of the 80 32-bit words, from LSB to MSB can be
                  found in the EGRET_ALERTS list in `rules/const.bzl`.
                  See the alert_handler documentation for more details.
                  '''
                isdigest: false
                iszer: false
                ismubi: false
                iskeymgr_creator: false
                iskeymgr_owner: false
                absorb: false
                inv_default: 0
                offset: 472
              }
              {
                name: OWNER_SW_CFG_ROM_LOCAL_ALERT_CLASSIFICATION
                size: 64
                desc:
                  '''
                  Same as the `OWNER_SW_CFG_ROM_ALERT_CLASSIFICATION` field,
                  except these configuration correspond to the local alert
                  sources found in the `EGRET_LOC_ALERTS list in
                  `rules/const.bzl`.
                  '''
                isdigest: false
                iszer: false
                ismubi: false
                iskeymgr_creator: false
                iskeymgr_owner: false
                absorb: false
                inv_default: 0
                offset: 792
              }
              {
                name: OWNER_SW_CFG_ROM_ALERT_ACCUM_THRESH
                size: 16
                desc:
                  '''
                  The alert accumulation threshold values for each alert class
                  (A through D) of the alert_handler to be configured by the
                  ROM. This field consists of four 32-bit words encoding the
                  accumulation thresholds for each alert class A through D
                  arranged LSW to MSW. See the alert_handler documentation for
                  more details.
                  '''
                isdigest: false
                iszer: false
                ismubi: false
                iskeymgr_creator: false
                iskeymgr_owner: false
                absorb: false
                inv_default: 0
                offset: 856
              }
              {
                name: OWNER_SW_CFG_ROM_ALERT_TIMEOUT_CYCLES
                size: 16
                desc:
                  '''
                  Same as the `OWNER_SW_CFG_ROM_ALERT_ACCUM_THRESH` field,
                  except each value corresponds to the interrupt timeout
                  configuration of an alert class.
                  '''
                isdigest: false
                iszer: false
                ismubi: false
                iskeymgr_creator: false
                iskeymgr_owner: false
                absorb: false
                inv_default: 0
                offset: 872
              }
              {
                name: OWNER_SW_CFG_ROM_ALERT_PHASE_CYCLES
                size: 64
                desc:
                  '''
                  The alert escalation phase durations, measured in clock
                  cycles, the ROM will configure the four alert phases for
                  each alert class of the alert_handler. This field consists
                  of a contiguous 64-byte block, or an array of four 128-bit
                  fields. Each 128-bit subfield encodes four 32-bit words that
                  contain the alert phase cycle count configurations for alert
                  escalation phases 0 to 3, from LSW to MSW. Each 128-bit
                  subfield is contains all configurations for a single alert
                  class, arranged from class A to D, from LS to MS. For
                  example, the cycle durations of each escalation phase in
                  this field should be configured as such, from LSB to MSB:
                  <classA,phase0>...<classA,phase3>...<classD,phase0>...
                  <classD,phase3>. See the alert_handler documentation for
                  more details.
                  '''
                isdigest: false
                iszer: false
                ismubi: false
                iskeymgr_creator: false
                iskeymgr_owner: false
                absorb: false
                inv_default: 0
                offset: 888
              }
              {
                name: OWNER_SW_CFG_ROM_ALERT_DIGEST_PROD
                size: 4
                desc:
                  '''
                  The expected CRC32 digest over all of the alert_handler
                  configurations set up by the ROM for a device operating in
                  the PROD LC state. The ROM reads this field and checks it
                  against a digest it computes over the alert_handler
                  configuration it programmed. This field is expected to be
                  automatically computed by the `otp_alert_digest()` Bazel
                  rule. See the `alert_config_crc32()` function in the
                  SiliconCreator alert_handler driver for more details on what
                  configurations are included in this digest.
                  '''
                isdigest: false
                iszer: false
                ismubi: false
                iskeymgr_creator: false
                iskeymgr_owner: false
                absorb: false
                inv_default: 0
                offset: 952
              }
              {
                name: OWNER_SW_CFG_ROM_ALERT_DIGEST_PROD_END
                size: 4
                desc:
                  '''
                  Same as the `OWNER_SW_CFG_ROM_ALERT_DIGEST_PROD` field,
                  except the expected digest is for chips operating in the
                  PROD_END LC state.
                  '''
                isdigest: false
                iszer: false
                ismubi: false
                iskeymgr_creator: false
                iskeymgr_owner: false
                absorb: false
                inv_default: 0
                offset: 956
              }
              {
                name: OWNER_SW_CFG_ROM_ALERT_DIGEST_DEV
                size: 4
                desc:
                  '''
                  Same as the `OWNER_SW_CFG_ROM_ALERT_DIGEST_PROD` field,
                  except the expected digest is for chips operating in the
                  DEV LC state.
                  '''
                isdigest: false
                iszer: false
                ismubi: false
                iskeymgr_creator: false
                iskeymgr_owner: false
                absorb: false
                inv_default: 0
                offset: 960
              }
              {
                name: OWNER_SW_CFG_ROM_ALERT_DIGEST_RMA
                size: 4
                desc:
                  '''
                  Same as the `OWNER_SW_CFG_ROM_ALERT_DIGEST_PROD` field,
                  except the expected digest is for chips operating in the
                  RMA LC state.
                  '''
                isdigest: false
                iszer: false
                ismubi: false
                iskeymgr_creator: false
                iskeymgr_owner: false
                absorb: false
                inv_default: 0
                offset: 964
              }
              {
                name: OWNER_SW_CFG_ROM_WATCHDOG_BITE_THRESHOLD_CYCLES
                size: 4
                desc: Watchdog timer bite threshold (in cycles) configured by the ROM.
                isdigest: false
                iszer: false
                ismubi: false
                iskeymgr_creator: false
                iskeymgr_owner: false
                absorb: false
                inv_default: 0
                offset: 968
              }
              {
                name: OWNER_SW_CFG_ROM_KEYMGR_OTP_MEAS_EN
                size: 4
                desc:
                  '''
                  Whether or not to configure the attestation SW binding CSRs
                  of the keymgr with the value in ROM_EXT manifest or the
                  measurement of the OTP CreatorSwCfg, OwnerSwCfg, and
                  secure boot key integrity digest. A value of
                  kHardenedBoolTrue uses the ROM computed OTP measurements,
                  while all other values trigger the use of the binding values
                  included in the ROM_EXT manifest.
                  '''
                isdigest: false
                iszer: false
                ismubi: false
                iskeymgr_creator: false
                iskeymgr_owner: false
                absorb: false
                inv_default: 0
                offset: 972
              }
              {
                name: OWNER_SW_CFG_MANUF_STATE
                size: 4
                desc:
                  '''
                  Manufacturing state binding field. For use by
                  SiliconCreators or SiliconOwners to bind BL0 images to a
                  specific device or set of devices.
                  '''
                isdigest: false
                iszer: false
                ismubi: false
                iskeymgr_creator: false
                iskeymgr_owner: false
                absorb: false
                inv_default: 0
                offset: 976
              }
              {
                name: OWNER_SW_CFG_ROM_RSTMGR_INFO_EN
                size: 4
                desc:
                  '''
                  A two byte packed word that indicates the expected rstmgr
                  alert and CPU info dump enable states, configured in the
                  rstmgr's ALERT_INFO_CTRL and CPU_INFO_CTRL CSRs respectively.
                  The expected format of this fields is
                  {0,0,kHardenedBool*,kHardenedBool*}, read MSB to LSB, where
                  the left most kHardenedBool* entry indicates the expected
                  enablement state of the ALERT_INFO_CTRL, and the right most
                  indicates the enablement state of the CPU_INFO_CTRL. Since
                  the ROM expects both to be disabled upon handing over
                  execution control to the ROM_EXT, this entire OTP field
                  **should be left unprovisioned, or set to all 0**.
                  '''
                isdigest: false
                iszer: false
                ismubi: false
                iskeymgr_creator: false
                iskeymgr_owner: false
                absorb: false
                inv_default: 0
                offset: 980
              }
              {
                name: OWNER_SW_CFG_ROM_SENSOR_CTRL_ALERT_CFG
                size: 12
                desc:
                  '''
                  Alert configuration values for the sensor_ctrl block
                  that will be configured by the ROM. This field is 12 bytes
                  long, where each byte contains two 4-bit packed subfields,
                  encoding two four bit boolean values (kMultiBitBool4False or
                  kMultiBitBool4True), as follows (read MSB to LSB):
                  {fatality, enablement}. For example, the byte 0x69 would
                  encode the alert is: 1) recoverable, and 2) disabled.

                  Currently, there are only 11 alerts in sensor_ctrl to
                  configure, thus only the least significant bytes in this
                  field are used.
                  '''
                isdigest: false
                iszer: false
                ismubi: false
                iskeymgr_creator: false
                iskeymgr_owner: false
                absorb: false
                inv_default: 0
                offset: 984
              }
              {
                name: OWNER_SW_CFG_ROM_SRAM_READBACK_EN
                size: 4
                desc:
                  '''
                  This field encodes the enablements of the readback security
                  features for the main and retention SRAMs to be configured
                  by the ROM. This field is four bytes, but the LSB contains
                  two 4-bit packed kMultiBitBool4* values that indicate the
                  enablement of the feature for the retention SRAM and
                  main SRAM, from MSB to LSB respectively. See the READBACK
                  CSR of the sram_ctrl for more details on this feature.
                  '''
                isdigest: false
                iszer: false
                ismubi: false
                iskeymgr_creator: false
                iskeymgr_owner: false
                absorb: false
                inv_default: 0
                offset: 996
              }
              {
                name: OWNER_SW_CFG_ROM_FLASH_ECC_EXC_HANDLER_EN
                size: 4
                desc:
                  '''
                  Whether or not the ROM should use the flash ECC exception
                  handler during execution. A value of kHardenedBoolTrue
                  allows the ROM to use an the exception handler that recovers
                  gracefully and continues the boot process if a flash ECC
                  error is encountered during verification of a specific
                  ROM_EXT slot. This enables the ROM to attempt booting the
                  next ROM_EXT slot if the first slot attempted has been
                  corrupted. All other values trigger default ROM exception
                  handling, which is all exceptions trigger a chip shutdown
                  and reset.
                  '''
                isdigest: false
                iszer: false
                ismubi: false
                iskeymgr_creator: false
                iskeymgr_owner: false
                absorb: false
                inv_default: 0
                offset: 1000
              }
              {
                name: OWNER_SW_CFG_DIGEST
                size: 8
                offset: 1088
                ismubi: false
                isdigest: true
                iszer: false
                inv_default: 18239385572812637686
                iskeymgr_creator: false
                iskeymgr_owner: false
              }
            ]
            desc:
              '''
              Software configuration partition.
              This contains data that changes software behavior in the ROM, for
              example enabling defensive features in ROM or selecting failure
              modes if verification fails.
              '''
            iskeymgr_creator: false
            iskeymgr_owner: false
            zeroizable: false
            ignore_read_lock_in_rma: false
            size: 640
            offset: 456
          }
          {
            name: OWNERSHIP_SLOT_STATE
            variant: Unbuffered
            absorb: false
            secret: false
            sw_digest: false
            hw_digest: false
            write_lock: None
            read_lock: CSR
            key_sel: NoKey
            integrity: true
            bkout_type: false
            zeroizable: true
            items:
            [
              {
                name: OWNERSHIP_SLOT_STATE_ZER
                size: 8
                offset: 1096
                ismubi: false
                isdigest: false
                iszer: true
                inv_default: 0
                iskeymgr_creator: false
                iskeymgr_owner: false
              }
            ]
            iskeymgr_creator: false
            iskeymgr_owner: false
            ignore_read_lock_in_rma: false
            size: 8
            offset: 1096
          }
          {
            name: ROT_CREATOR_IDENTITY
            variant: Unbuffered
            absorb: false
            secret: false
            sw_digest: true
            hw_digest: false
            write_lock: Digest
            read_lock: CSR
            key_sel: NoKey
            integrity: true
            bkout_type: false
            zeroizable: true
            items:
            [
              {
                name: ROT_CREATOR_IDENTITY_CERT
                size: 768
                desc:
                  '''
                  RoT Device Identity Certificate endorsed by the Silicon Creator stable PKI (off device).
                  It is expected to be provisioned at Factory Testing (FT) stage when LC = DEV or PROD.
                  Provisioning happens through a secured channel between the DUT and the HSM, i.e. the key
                  is protected against supply-chain and manufacturing attacks.
                  '''
                isdigest: false
                iszer: false
                ismubi: false
                iskeymgr_creator: false
                iskeymgr_owner: false
                absorb: false
                inv_default: 0
                offset: 1104
              }
              {
                name: ROT_CREATOR_IDENTITY_CERT_CMAC
                size: 16
                desc: A Cipher-based MAC for the RoT Device Identity Certificate.
                isdigest: false
                iszer: false
                ismubi: false
                iskeymgr_creator: false
                iskeymgr_owner: false
                absorb: false
                inv_default: 0
                offset: 1872
              }
              {
                name: ROT_CREATOR_IDENTITY_DIGEST
                size: 8
                offset: 1888
                ismubi: false
                isdigest: true
                iszer: false
                inv_default: 7388996329285901817
                iskeymgr_creator: false
                iskeymgr_owner: false
              }
              {
                name: ROT_CREATOR_IDENTITY_ZER
                size: 8
                offset: 1896
                ismubi: false
                isdigest: false
                iszer: true
                inv_default: 0
                iskeymgr_creator: false
                iskeymgr_owner: false
              }
            ]
            desc: Software managed partition for the RoT Creator identity.
            iskeymgr_creator: false
            iskeymgr_owner: false
            ignore_read_lock_in_rma: false
            size: 800
            offset: 1104
          }
          {
            name: ROT_OWNER_AUTH_SLOT0
            variant: Unbuffered
            absorb: false
            secret: false
            sw_digest: true
            hw_digest: false
            write_lock: Digest
            read_lock: CSR
            key_sel: NoKey
            integrity: true
            bkout_type: false
            zeroizable: true
            items:
            [
              {
                name: ROT_OWNER_AUTH_SLOT0_FIRMWARE_CODESIGN_KEY_TYPE
                size: 4
                desc:
                  '''
                  Key usage type. One of the following 32-bit values defined
                  by the sigverify API:
                  - kSigverifyKeyTypeTest for manufacturing, testing and RMA keys.
                    Keys of this type can be used only in TEST_UNLOCKED* and RMA life
                    cycle states.
                  - kSigverifyKeyTypeProd for production keys.
                    Keys of this type can be used in all operational life cycle states, i.e.
                    states in which CPU execution is enabled.
                  - kSigverifyKeyTypeDev for development keys.
                    Keys of this type can be used only in the DEV life cycle state.
                  '''
                isdigest: false
                iszer: false
                ismubi: false
                iskeymgr_creator: false
                iskeymgr_owner: false
                absorb: false
                inv_default: 0
                offset: 1904
              }
              {
                name: ROT_OWNER_AUTH_SLOT0_FIRMWARE_CODESIGN_ECDSA_KEY
                size: 64
                desc:
                  '''
                  ECDSA public key used to verify firmware images.
                  Key Type: ECC NIST-P256 Curve.
                  It is expected to be provisioned at Final Test (FT) stage when LC = TEST_UNLOCKED.
                  '''
                isdigest: false
                iszer: false
                ismubi: false
                iskeymgr_creator: false
                iskeymgr_owner: false
                absorb: false
                inv_default: 0
                offset: 1908
              }
              {
                name: ROT_OWNER_AUTH_SLOT0_FIRMWARE_CODESIGN_SPX_KEY
                size: 32
                desc:
                  '''
                  SPHINCS+ public key used to verify firmware images.
                  Key Type: SPHINCS+, see modes in ROT_OWNER_AUTH_SLOT0_FIRMWARE_CODESIGN_SPX_KEY_CONFIG.
                  It is expected to be provisioned at Final Test (FT) stage when LC = TEST_UNLOCKED.
                  '''
                isdigest: false
                iszer: false
                ismubi: false
                iskeymgr_creator: false
                iskeymgr_owner: false
                absorb: false
                inv_default: 0
                offset: 1972
              }
              {
                name: ROT_OWNER_AUTH_SLOT0_FIRMWARE_CODESIGN_SPX_KEY_CONFIG
                size: 4
                desc:
                  '''
                  Configuration value for ROT_OWNER_AUTH_SLOT0_FIRMWARE_CODESIGN_SPX_KEY:
                  - kSigverifySpxConfigIdSha2128s: SPHINCS+-SHA2-128s without pre-hashing.
                  - kSigverifySpxConfigIdSha2128sQ20: SPHINCS+-SHA2-128s-q20 without pre-hashing
                  - kSigverifySpxConfigIdSha2128sPrehash: SPHINCS+-SHA2-128s with SHA256 pre-hashing.
                  - kSigverifySpxConfigIdSha2128sQ20Prehash: SPHINCS+-SHA2-128s-q20 with SHA256 pre-hashing.
                  '''
                isdigest: false
                iszer: false
                ismubi: false
                iskeymgr_creator: false
                iskeymgr_owner: false
                absorb: false
                inv_default: 0
                offset: 2004
              }
              {
                name: ROT_OWNER_AUTH_SLOT0_DIGEST
                size: 8
                offset: 2008
                ismubi: false
                isdigest: true
                iszer: false
                inv_default: 17014664945089674915
                iskeymgr_creator: false
                iskeymgr_owner: false
              }
              {
                name: ROT_OWNER_AUTH_SLOT0_ZER
                size: 8
                offset: 2016
                ismubi: false
                isdigest: false
                iszer: true
                inv_default: 0
                iskeymgr_creator: false
                iskeymgr_owner: false
              }
            ]
            desc: Software managed partition for a RoT Owner (a.k.a. Silicon Creator) key manifest.
            iskeymgr_creator: false
            iskeymgr_owner: false
            ignore_read_lock_in_rma: false
            size: 120
            offset: 1904
          }
          {
            name: ROT_OWNER_AUTH_SLOT1
            variant: Unbuffered
            absorb: false
            secret: false
            sw_digest: true
            hw_digest: false
            write_lock: Digest
            read_lock: CSR
            key_sel: NoKey
            integrity: true
            bkout_type: false
            zeroizable: true
            items:
            [
              {
                name: ROT_OWNER_AUTH_SLOT1_FIRMWARE_CODESIGN_KEY_TYPE
                size: 4
                desc:
                  '''
                  Key usage type. One of the following 32-bit values defined
                  by the sigverify API:
                  - kSigverifyKeyTypeTest for manufacturing, testing and RMA keys.
                    Keys of this type can be used only in TEST_UNLOCKED* and RMA life
                    cycle states.
                  - kSigverifyKeyTypeProd for production keys.
                    Keys of this type can be used in all operational life cycle states, i.e.
                    states in which CPU execution is enabled.
                  - kSigverifyKeyTypeDev for development keys.
                    Keys of this type can be used only in the DEV life cycle state.
                  '''
                isdigest: false
                iszer: false
                ismubi: false
                iskeymgr_creator: false
                iskeymgr_owner: false
                absorb: false
                inv_default: 0
                offset: 2024
              }
              {
                name: ROT_OWNER_AUTH_SLOT1_FIRMWARE_CODESIGN_ECDSA_KEY
                size: 64
                desc:
                  '''
                  ECDSA public key used to verify firmware images.
                  Key Type: ECC NIST-P256 Curve.
                  It is expected to be provisioned at Final Test (FT) stage when LC = TEST_UNLOCKED.
                  '''
                isdigest: false
                iszer: false
                ismubi: false
                iskeymgr_creator: false
                iskeymgr_owner: false
                absorb: false
                inv_default: 0
                offset: 2028
              }
              {
                name: ROT_OWNER_AUTH_SLOT1_FIRMWARE_CODESIGN_SPX_KEY
                size: 32
                desc:
                  '''
                  SPHINCS+ public key used to verify firmware images.
                  Key Type: SPHINCS+, see modes in ROT_OWNER_AUTH_SLOT1_FIRMWARE_CODESIGN_SPX_KEY_CONFIG.
                  It is expected to be provisioned at Final Test (FT) stage when LC = TEST_UNLOCKED.
                  '''
                isdigest: false
                iszer: false
                ismubi: false
                iskeymgr_creator: false
                iskeymgr_owner: false
                absorb: false
                inv_default: 0
                offset: 2092
              }
              {
                name: ROT_OWNER_AUTH_SLOT1_FIRMWARE_CODESIGN_SPX_KEY_CONFIG
                size: 4
                desc:
                  '''
                  Configuration value for ROT_OWNER_AUTH_SLOT1_FIRMWARE_CODESIGN_SPX_KEY:
                  - kSigverifySpxConfigIdSha2128s: SPHINCS+-SHA2-128s without pre-hashing.
                  - kSigverifySpxConfigIdSha2128sQ20: SPHINCS+-SHA2-128s-q20 without pre-hashing
                  - kSigverifySpxConfigIdSha2128sPrehash: SPHINCS+-SHA2-128s with SHA256 pre-hashing.
                  - kSigverifySpxConfigIdSha2128sQ20Prehash: SPHINCS+-SHA2-128s-q20 with SHA256 pre-hashing.
                  '''
                isdigest: false
                iszer: false
                ismubi: false
                iskeymgr_creator: false
                iskeymgr_owner: false
                absorb: false
                inv_default: 0
                offset: 2124
              }
              {
                name: ROT_OWNER_AUTH_SLOT1_DIGEST
                size: 8
                offset: 2128
                ismubi: false
                isdigest: true
                iszer: false
                inv_default: 17787990554517712170
                iskeymgr_creator: false
                iskeymgr_owner: false
              }
              {
                name: ROT_OWNER_AUTH_SLOT1_ZER
                size: 8
                offset: 2136
                ismubi: false
                isdigest: false
                iszer: true
                inv_default: 0
                iskeymgr_creator: false
                iskeymgr_owner: false
              }
            ]
            desc: Software managed partition for a RoT Owner (a.k.a. Silicon Creator) key manifest.
            iskeymgr_creator: false
            iskeymgr_owner: false
            ignore_read_lock_in_rma: false
            size: 120
            offset: 2024
          }
          {
            name: ROT_OWNER_AUTH_SLOT2
            variant: Unbuffered
            absorb: false
            secret: false
            sw_digest: true
            hw_digest: false
            write_lock: Digest
            read_lock: CSR
            key_sel: NoKey
            integrity: true
            bkout_type: false
            zeroizable: true
            items:
            [
              {
                name: ROT_OWNER_AUTH_SLOT2_FIRMWARE_CODESIGN_KEY_TYPE
                size: 4
                desc:
                  '''
                  Key usage type. One of the following 32-bit values defined
                  by the sigverify API:
                  - kSigverifyKeyTypeTest for manufacturing, testing and RMA keys.
                    Keys of this type can be used only in TEST_UNLOCKED* and RMA life
                    cycle states.
                  - kSigverifyKeyTypeProd for production keys.
                    Keys of this type can be used in all operational life cycle states, i.e.
                    states in which CPU execution is enabled.
                  - kSigverifyKeyTypeDev for development keys.
                    Keys of this type can be used only in the DEV life cycle state.
                  '''
                isdigest: false
                iszer: false
                ismubi: false
                iskeymgr_creator: false
                iskeymgr_owner: false
                absorb: false
                inv_default: 0
                offset: 2144
              }
              {
                name: ROT_OWNER_AUTH_SLOT2_FIRMWARE_CODESIGN_ECDSA_KEY
                size: 64
                desc:
                  '''
                  ECDSA public key used to verify firmware images.
                  Key Type: ECC NIST-P256 Curve.
                  It is expected to be provisioned at Final Test (FT) stage when LC = TEST_UNLOCKED.
                  '''
                isdigest: false
                iszer: false
                ismubi: false
                iskeymgr_creator: false
                iskeymgr_owner: false
                absorb: false
                inv_default: 0
                offset: 2148
              }
              {
                name: ROT_OWNER_AUTH_SLOT2_FIRMWARE_CODESIGN_SPX_KEY
                size: 32
                desc:
                  '''
                  SPHINCS+ public key used to verify firmware images.
                  Key Type: SPHINCS+, see modes in ROT_OWNER_AUTH_SLOT2_FIRMWARE_CODESIGN_SPX_KEY_CONFIG.
                  It is expected to be provisioned at Final Test (FT) stage when LC = TEST_UNLOCKED.
                  '''
                isdigest: false
                iszer: false
                ismubi: false
                iskeymgr_creator: false
                iskeymgr_owner: false
                absorb: false
                inv_default: 0
                offset: 2212
              }
              {
                name: ROT_OWNER_AUTH_SLOT2_FIRMWARE_CODESIGN_SPX_KEY_CONFIG
                size: 4
                desc:
                  '''
                  Configuration value for ROT_OWNER_AUTH_SLOT2_FIRMWARE_CODESIGN_SPX_KEY:
                  - kSigverifySpxConfigIdSha2128s: SPHINCS+-SHA2-128s without pre-hashing.
                  - kSigverifySpxConfigIdSha2128sQ20: SPHINCS+-SHA2-128s-q20 without pre-hashing
                  - kSigverifySpxConfigIdSha2128sPrehash: SPHINCS+-SHA2-128s with SHA256 pre-hashing.
                  - kSigverifySpxConfigIdSha2128sQ20Prehash: SPHINCS+-SHA2-128s-q20 with SHA256 pre-hashing.
                  '''
                isdigest: false
                iszer: false
                ismubi: false
                iskeymgr_creator: false
                iskeymgr_owner: false
                absorb: false
                inv_default: 0
                offset: 2244
              }
              {
                name: ROT_OWNER_AUTH_SLOT2_DIGEST
                size: 8
                offset: 2248
                ismubi: false
                isdigest: true
                iszer: false
                inv_default: 13248414165649443033
                iskeymgr_creator: false
                iskeymgr_owner: false
              }
              {
                name: ROT_OWNER_AUTH_SLOT2_ZER
                size: 8
                offset: 2256
                ismubi: false
                isdigest: false
                iszer: true
                inv_default: 0
                iskeymgr_creator: false
                iskeymgr_owner: false
              }
            ]
            desc: Software managed partition for a RoT Owner (a.k.a. Silicon Creator) key manifest.
            iskeymgr_creator: false
            iskeymgr_owner: false
            ignore_read_lock_in_rma: false
            size: 120
            offset: 2144
          }
          {
            name: ROT_OWNER_AUTH_SLOT3
            variant: Unbuffered
            absorb: false
            secret: false
            sw_digest: true
            hw_digest: false
            write_lock: Digest
            read_lock: CSR
            key_sel: NoKey
            integrity: true
            bkout_type: false
            zeroizable: true
            items:
            [
              {
                name: ROT_OWNER_AUTH_SLOT3_FIRMWARE_CODESIGN_KEY_TYPE
                size: 4
                desc:
                  '''
                  Key usage type. One of the following 32-bit values defined
                  by the sigverify API:
                  - kSigverifyKeyTypeTest for manufacturing, testing and RMA keys.
                    Keys of this type can be used only in TEST_UNLOCKED* and RMA life
                    cycle states.
                  - kSigverifyKeyTypeProd for production keys.
                    Keys of this type can be used in all operational life cycle states, i.e.
                    states in which CPU execution is enabled.
                  - kSigverifyKeyTypeDev for development keys.
                    Keys of this type can be used only in the DEV life cycle state.
                  '''
                isdigest: false
                iszer: false
                ismubi: false
                iskeymgr_creator: false
                iskeymgr_owner: false
                absorb: false
                inv_default: 0
                offset: 2264
              }
              {
                name: ROT_OWNER_AUTH_SLOT3_FIRMWARE_CODESIGN_ECDSA_KEY
                size: 64
                desc:
                  '''
                  ECDSA public key used to verify firmware images.
                  Key Type: ECC NIST-P256 Curve.
                  It is expected to be provisioned at Final Test (FT) stage when LC = TEST_UNLOCKED.
                  '''
                isdigest: false
                iszer: false
                ismubi: false
                iskeymgr_creator: false
                iskeymgr_owner: false
                absorb: false
                inv_default: 0
                offset: 2268
              }
              {
                name: ROT_OWNER_AUTH_SLOT3_FIRMWARE_CODESIGN_SPX_KEY
                size: 32
                desc:
                  '''
                  SPHINCS+ public key used to verify firmware images.
                  Key Type: SPHINCS+, see modes in ROT_OWNER_AUTH_SLOT3_FIRMWARE_CODESIGN_SPX_KEY_CONFIG.
                  It is expected to be provisioned at Final Test (FT) stage when LC = TEST_UNLOCKED.
                  '''
                isdigest: false
                iszer: false
                ismubi: false
                iskeymgr_creator: false
                iskeymgr_owner: false
                absorb: false
                inv_default: 0
                offset: 2332
              }
              {
                name: ROT_OWNER_AUTH_SLOT3_FIRMWARE_CODESIGN_SPX_KEY_CONFIG
                size: 4
                desc:
                  '''
                  Configuration value for ROT_OWNER_AUTH_SLOT3_FIRMWARE_CODESIGN_SPX_KEY:
                  - kSigverifySpxConfigIdSha2128s: SPHINCS+-SHA2-128s without pre-hashing.
                  - kSigverifySpxConfigIdSha2128sQ20: SPHINCS+-SHA2-128s-q20 without pre-hashing
                  - kSigverifySpxConfigIdSha2128sPrehash: SPHINCS+-SHA2-128s with SHA256 pre-hashing.
                  - kSigverifySpxConfigIdSha2128sQ20Prehash: SPHINCS+-SHA2-128s-q20 with SHA256 pre-hashing.
                  '''
                isdigest: false
                iszer: false
                ismubi: false
                iskeymgr_creator: false
                iskeymgr_owner: false
                absorb: false
                inv_default: 0
                offset: 2364
              }
              {
                name: ROT_OWNER_AUTH_SLOT3_DIGEST
                size: 8
                offset: 2368
                ismubi: false
                isdigest: true
                iszer: false
                inv_default: 5835184937972759951
                iskeymgr_creator: false
                iskeymgr_owner: false
              }
              {
                name: ROT_OWNER_AUTH_SLOT3_ZER
                size: 8
                offset: 2376
                ismubi: false
                isdigest: false
                iszer: true
                inv_default: 0
                iskeymgr_creator: false
                iskeymgr_owner: false
              }
            ]
            desc: Software managed partition for a RoT Owner (a.k.a. Silicon Creator) key manifest.
            iskeymgr_creator: false
            iskeymgr_owner: false
            ignore_read_lock_in_rma: false
            size: 120
            offset: 2264
          }
          {
            name: ROT_OWNER_AUTH_SLOT0_STATE
            variant: Unbuffered
            absorb: false
            secret: false
            sw_digest: true
            hw_digest: false
            write_lock: Digest
            read_lock: CSR
            key_sel: NoKey
            integrity: true
            bkout_type: false
            items:
            [
              {
                name: ROT_OWNER_AUTH_SLOT0_STATE_FIRMWARE_CODESIGN_ECDSA_KEY_STATE
                size: 4
                desc: Enablement state of the firmware verification ECDSA key in ROT_OWNER_AUTH_SLOT0.
                isdigest: false
                iszer: false
                ismubi: false
                iskeymgr_creator: false
                iskeymgr_owner: false
                absorb: false
                inv_default: 0
                offset: 2384
              }
              {
                name: ROT_OWNER_AUTH_SLOT0_STATE_FIRMWARE_CODESIGN_SPX_KEY_STATE
                size: 4
                desc: Enablement state of the firmware verification SPHINCS+ key in ROT_OWNER_AUTH_SLOT0.
                isdigest: false
                iszer: false
                ismubi: false
                iskeymgr_creator: false
                iskeymgr_owner: false
                absorb: false
                inv_default: 0
                offset: 2388
              }
              {
                name: ROT_OWNER_AUTH_SLOT0_STATE_ROM1_PATCH_ECDSA_KEY_STATE
                size: 4
                desc: Enablement state of the second ROM patch ECDSA key in ROT_OWNER_AUTH_SLOT0.
                isdigest: false
                iszer: false
                ismubi: false
                iskeymgr_creator: false
                iskeymgr_owner: false
                absorb: false
                inv_default: 0
                offset: 2392
              }
              {
                name: ROT_OWNER_AUTH_SLOT0_STATE_ROM1_PATCH_SPX_KEY_STATE
                size: 4
                desc: Enablement state of the second ROM patch SPHINCS+ key in ROT_OWNER_AUTH_SLOT0.
                isdigest: false
                iszer: false
                ismubi: false
                iskeymgr_creator: false
                iskeymgr_owner: false
                absorb: false
                inv_default: 0
                offset: 2396
              }
              {
                name: ROT_OWNER_AUTH_SLOT0_STATE_DIGEST
                size: 8
                offset: 2400
                ismubi: false
                isdigest: true
                iszer: false
                inv_default: 18410855119173665658
                iskeymgr_creator: false
                iskeymgr_owner: false
              }
            ]
            desc:
              '''
              This OTP partition is used to capture the state of each key in ROT_OWNER_AUTH_SLOT0.
              Each key can be in one of the following states: BLANK, ENABLED, DISABLED. The
              encoded values are such that transitions between BLANK -> ENABLED ->  DISABLED are
              Possible without causing ECC errors (this is a mechanism similar to how we manage
              life cycle state transitions). The partition is left unlocked to allow STATE
              updates in the field. The ROM_EXT is required to lock access to the OTP Direct
              Access Interface to prevent DoS attacks from malicious code executing on Silicon
              Owner partitions. DAI write locking is available.
              '''
            iskeymgr_creator: false
            iskeymgr_owner: false
            zeroizable: false
            ignore_read_lock_in_rma: false
            size: 24
            offset: 2384
          }
          {
            name: ROT_OWNER_AUTH_SLOT1_STATE
            variant: Unbuffered
            absorb: false
            secret: false
            sw_digest: true
            hw_digest: false
            write_lock: Digest
            read_lock: CSR
            key_sel: NoKey
            integrity: true
            bkout_type: false
            items:
            [
              {
                name: ROT_OWNER_AUTH_SLOT1_STATE_FIRMWARE_CODESIGN_ECDSA_KEY_STATE
                size: 4
                desc: Enablement state of the firmware verification ECDSA key in ROT_OWNER_AUTH_SLOT1.
                isdigest: false
                iszer: false
                ismubi: false
                iskeymgr_creator: false
                iskeymgr_owner: false
                absorb: false
                inv_default: 0
                offset: 2408
              }
              {
                name: ROT_OWNER_AUTH_SLOT1_STATE_FIRMWARE_CODESIGN_SPX_KEY_STATE
                size: 4
                desc: Enablement state of the firmware verification SPHINCS+ key in ROT_OWNER_AUTH_SLOT1.
                isdigest: false
                iszer: false
                ismubi: false
                iskeymgr_creator: false
                iskeymgr_owner: false
                absorb: false
                inv_default: 0
                offset: 2412
              }
              {
                name: ROT_OWNER_AUTH_SLOT1_STATE_ROM1_PATCH_ECDSA_KEY_STATE
                size: 4
                desc: Enablement state of the second ROM patch ECDSA key in ROT_OWNER_AUTH_SLOT1.
                isdigest: false
                iszer: false
                ismubi: false
                iskeymgr_creator: false
                iskeymgr_owner: false
                absorb: false
                inv_default: 0
                offset: 2416
              }
              {
                name: ROT_OWNER_AUTH_SLOT1_STATE_ROM1_PATCH_SPX_KEY_STATE
                size: 4
                desc: Enablement state of the second ROM patch SPHINCS+ key in ROT_OWNER_AUTH_SLOT1.
                isdigest: false
                iszer: false
                ismubi: false
                iskeymgr_creator: false
                iskeymgr_owner: false
                absorb: false
                inv_default: 0
                offset: 2420
              }
              {
                name: ROT_OWNER_AUTH_SLOT1_STATE_DIGEST
                size: 8
                offset: 2424
                ismubi: false
                isdigest: true
                iszer: false
                inv_default: 17765946314086229411
                iskeymgr_creator: false
                iskeymgr_owner: false
              }
            ]
            desc:
              '''
              This OTP partition is used to capture the state of each key in ROT_OWNER_AUTH_SLOT1.
              Each key can be in one of the following states: BLANK, ENABLED, DISABLED. The
              encoded values are such that transitions between BLANK -> ENABLED ->  DISABLED are
              Possible without causing ECC errors (this is a mechanism similar to how we manage
              life cycle state transitions). The partition is left unlocked to allow STATE
              updates in the field. The ROM_EXT is required to lock access to the OTP Direct
              Access Interface to prevent DoS attacks from malicious code executing on Silicon
              Owner partitions. DAI write locking is available.
              '''
            iskeymgr_creator: false
            iskeymgr_owner: false
            zeroizable: false
            ignore_read_lock_in_rma: false
            size: 24
            offset: 2408
          }
          {
            name: ROT_OWNER_AUTH_SLOT2_STATE
            variant: Unbuffered
            absorb: false
            secret: false
            sw_digest: true
            hw_digest: false
            write_lock: Digest
            read_lock: CSR
            key_sel: NoKey
            integrity: true
            bkout_type: false
            items:
            [
              {
                name: ROT_OWNER_AUTH_SLOT2_STATE_FIRMWARE_CODESIGN_ECDSA_KEY_STATE
                size: 4
                desc: Enablement state of the firmware verification ECDSA key in ROT_OWNER_AUTH_SLOT2.
                isdigest: false
                iszer: false
                ismubi: false
                iskeymgr_creator: false
                iskeymgr_owner: false
                absorb: false
                inv_default: 0
                offset: 2432
              }
              {
                name: ROT_OWNER_AUTH_SLOT2_STATE_FIRMWARE_CODESIGN_SPX_KEY_STATE
                size: 4
                desc: Enablement state of the firmware verification SPHINCS+ key in ROT_OWNER_AUTH_SLOT2.
                isdigest: false
                iszer: false
                ismubi: false
                iskeymgr_creator: false
                iskeymgr_owner: false
                absorb: false
                inv_default: 0
                offset: 2436
              }
              {
                name: ROT_OWNER_AUTH_SLOT2_STATE_DIGEST
                size: 8
                offset: 2440
                ismubi: false
                isdigest: true
                iszer: false
                inv_default: 5776996463561863949
                iskeymgr_creator: false
                iskeymgr_owner: false
              }
            ]
            desc:
              '''
              This OTP partition is used to capture the state of each key in ROT_OWNER_AUTH_SLOT2.
              Each key can be in one of the following states: BLANK, ENABLED, DISABLED. The
              encoded values are such that transitions between BLANK -> ENABLED ->  DISABLED are
              Possible without causing ECC errors (this is a mechanism similar to how we manage
              life cycle state transitions). The partition is left unlocked to allow STATE
              updates in the field. The ROM_EXT is required to lock access to the OTP Direct
              Access Interface to prevent DoS attacks from malicious code executing on Silicon
              Owner partitions. DAI write locking is available.
              '''
            iskeymgr_creator: false
            iskeymgr_owner: false
            zeroizable: false
            ignore_read_lock_in_rma: false
            size: 16
            offset: 2432
          }
          {
            name: ROT_OWNER_AUTH_SLOT3_STATE
            variant: Unbuffered
            absorb: false
            secret: false
            sw_digest: true
            hw_digest: false
            write_lock: Digest
            read_lock: CSR
            key_sel: NoKey
            integrity: true
            bkout_type: false
            items:
            [
              {
                name: ROT_OWNER_AUTH_SLOT3_STATE_FIRMWARE_CODESIGN_ECDSA_KEY_STATE
                size: 4
                desc: Enablement state of the firmware verification ECDSA key in ROT_OWNER_AUTH_SLOT3.
                isdigest: false
                iszer: false
                ismubi: false
                iskeymgr_creator: false
                iskeymgr_owner: false
                absorb: false
                inv_default: 0
                offset: 2448
              }
              {
                name: ROT_OWNER_AUTH_SLOT3_STATE_FIRMWARE_CODESIGN_SPX_KEY_STATE
                size: 4
                desc: Enablement state of the firmware verification SPHINCS+ key in ROT_OWNER_AUTH_SLOT3.
                isdigest: false
                iszer: false
                ismubi: false
                iskeymgr_creator: false
                iskeymgr_owner: false
                absorb: false
                inv_default: 0
                offset: 2452
              }
              {
                name: ROT_OWNER_AUTH_SLOT3_STATE_DIGEST
                size: 8
                offset: 2456
                ismubi: false
                isdigest: true
                iszer: false
                inv_default: 16772361003296535520
                iskeymgr_creator: false
                iskeymgr_owner: false
              }
            ]
            desc:
              '''
              This OTP partition is used to capture the state of each key in ROT_OWNER_AUTH_SLOT3.
              Each key can be in one of the following states: BLANK, ENABLED, DISABLED. The
              encoded values are such that transitions between BLANK -> ENABLED ->  DISABLED are
              Possible without causing ECC errors (this is a mechanism similar to how we manage
              life cycle state transitions). The partition is left unlocked to allow STATE
              updates in the field. The ROM_EXT is required to lock access to the OTP Direct
              Access Interface to prevent DoS attacks from malicious code executing on Silicon
              Owner partitions. DAI write locking is available.
              '''
            iskeymgr_creator: false
            iskeymgr_owner: false
            zeroizable: false
            ignore_read_lock_in_rma: false
            size: 16
            offset: 2448
          }
          {
            name: EXT_NVM
            variant: Unbuffered
            absorb: false
            secret: false
            sw_digest: false
            hw_digest: false
            write_lock: None
            read_lock: CSR
            key_sel: NoKey
            integrity: false
            bkout_type: false
            zeroizable: true
            items:
            [
              {
                name: EXT_NVM_ANTIREPLAY_FRESHNESS_CNT
                size: 1024
                desc:
                  '''
                  Fully SW managed partition
                  1 bit (double bit allocated for redundancy - i.e. 2 physical bits for every logical bit) per day
                  assuming 10 year product lifecycle, allocating 8192 bits of freshness protection.
                  Implemented as thermometer encoding. Redundant bit programming & logical OR-ing managed by
                  software. Cannot be ECC protected since different bits in a fuse row are programmed at different times.
                  '''
                isdigest: false
                iszer: false
                ismubi: false
                iskeymgr_creator: false
                iskeymgr_owner: false
                absorb: false
                inv_default: 0
                offset: 2464
              }
              {
                name: EXT_NVM_ZER
                size: 8
                offset: 3488
                ismubi: false
                isdigest: false
                iszer: true
                inv_default: 0
                iskeymgr_creator: false
                iskeymgr_owner: false
              }
            ]
            desc: Anti-replay protection Strike Counters partition.
            iskeymgr_creator: false
            iskeymgr_owner: false
            ignore_read_lock_in_rma: false
            size: 1032
            offset: 2464
          }
          {
            name: ROM_PATCH
            variant: Unbuffered
            absorb: false
            secret: false
            sw_digest: true
            hw_digest: false
            write_lock: Digest
            read_lock: CSR
            key_sel: NoKey
            integrity: true
            bkout_type: false
            zeroizable: true
            items:
            [
              {
                name: ROM_PATCH_DIGEST
                size: 8
                offset: 3496
                ismubi: false
                isdigest: true
                iszer: false
                inv_default: 16239032379200962209
                iskeymgr_creator: false
                iskeymgr_owner: false
              }
              {
                name: ROM_PATCH_ZER
                size: 8
                offset: 3504
                ismubi: false
                isdigest: false
                iszer: true
                inv_default: 0
                iskeymgr_creator: false
                iskeymgr_owner: false
              }
            ]
            desc: Second ROM Patch Code section. May contain multiple signed ROM1 patches.
            iskeymgr_creator: false
            iskeymgr_owner: false
            ignore_read_lock_in_rma: false
            size: 16
            offset: 3496
          }
          {
            name: SOC_FUSES_CP
            variant: Unbuffered
            absorb: false
            secret: false
            sw_digest: true
            hw_digest: false
            write_lock: Digest
            read_lock: CSR
            key_sel: NoKey
            integrity: true
            bkout_type: false
            items:
            [
              {
                name: SOC_FUSES_CP_DIGEST
                size: 8
                offset: 3512
                ismubi: false
                isdigest: true
                iszer: false
                inv_default: 6748737775371490481
                iskeymgr_creator: false
                iskeymgr_owner: false
              }
            ]
            desc: SoC fuses partition for the Chip Probe (CP) manufacturing stage.
            iskeymgr_creator: false
            iskeymgr_owner: false
            zeroizable: false
            ignore_read_lock_in_rma: false
            size: 8
            offset: 3512
          }
          {
            name: SOC_FUSES_FT
            variant: Unbuffered
            absorb: false
            secret: false
            sw_digest: true
            hw_digest: false
            write_lock: Digest
            read_lock: CSR
            key_sel: NoKey
            integrity: true
            bkout_type: false
            items:
            [
              {
                name: SOC_FUSES_FT_DIGEST
                size: 8
                offset: 3520
                ismubi: false
                isdigest: true
                iszer: false
                inv_default: 7532579203220097263
                iskeymgr_creator: false
                iskeymgr_owner: false
              }
            ]
            desc: SoC fuses partition for the Factory Testing (FT) manufacturing stage.
            iskeymgr_creator: false
            iskeymgr_owner: false
            zeroizable: false
            ignore_read_lock_in_rma: false
            size: 8
            offset: 3520
          }
          {
            name: SCRATCH_FUSES
            variant: Unbuffered
            absorb: true
            secret: false
            sw_digest: false
            hw_digest: false
            write_lock: None
            read_lock: CSR
            key_sel: NoKey
            integrity: true
            bkout_type: false
            zeroizable: true
            items:
            [
              {
                name: SCRATCH_FUSES_DATA
                absorb: true
                desc:
                  '''
                  Fully SW managed partition.
                  Unstructured, single item partition for any RoT firmware (runtime,
                  bootstrap, manufacturing) to use and organize freely.
                  '''
                size: 72
                isdigest: false
                iszer: false
                ismubi: false
                iskeymgr_creator: false
                iskeymgr_owner: false
                inv_default: 0
                offset: 3528
              }
              {
                name: SCRATCH_FUSES_ZER
                size: 8
                offset: 3600
                ismubi: false
                isdigest: false
                iszer: true
                inv_default: 0
                iskeymgr_creator: false
                iskeymgr_owner: false
              }
            ]
            desc: Unstructured scratch data partition.
            iskeymgr_creator: false
            iskeymgr_owner: false
            ignore_read_lock_in_rma: false
            size: 80
            offset: 3528
          }
          {
            name: HW_CFG0
            variant: Buffered
            secret: false
            sw_digest: false
            hw_digest: true
            write_lock: Digest
            read_lock: None
            key_sel: NoKey
            integrity: true
            bkout_type: true
            skip_sw_header: true
            items:
            [
              {
                name: DEVICE_ID
                size: 32
                inv_default: 75416344968344595199184561357653563771667887286318218849004063607029244022168
                desc:
                  '''
                  Unique device identifier that is always exposed through the
                  lifecycle JTAG tap. See documentation on Device Identifiers.
                  '''
                isdigest: false
                iszer: false
                ismubi: false
                iskeymgr_creator: false
                iskeymgr_owner: false
                absorb: false
                offset: 3608
              }
              {
                name: HW_CFG0_DIGEST
                size: 8
                offset: 3640
                ismubi: false
                isdigest: true
                iszer: false
                inv_default: 12018756830038280371
                iskeymgr_creator: false
                iskeymgr_owner: false
              }
            ]
            desc:
              '''
              Hardware configuration 0 partition.
              This contains a device identifier and manufacturing state.
              '''
            absorb: false
            iskeymgr_creator: false
            iskeymgr_owner: false
            zeroizable: false
            ignore_read_lock_in_rma: false
            size: 40
            offset: 3608
          }
          {
            name: HW_CFG1
            variant: Buffered
            secret: false
            sw_digest: false
            hw_digest: true
            write_lock: Digest
            read_lock: None
            key_sel: NoKey
            integrity: true
            bkout_type: true
            skip_sw_header: true
            items:
            [
              {
                name: EN_SRAM_IFETCH
                size: 1
                ismubi: true
                inv_default: 105
                desc:
                  '''
                  Enablement of execute from SRAM switch in the sram_ctrl (see
                  EXEC CSR). A kMultiBitBool8True value enables, while all
                  other values disable.
                  '''
                isdigest: false
                iszer: false
                iskeymgr_creator: false
                iskeymgr_owner: false
                absorb: false
                offset: 3648
              }
              {
                name: EN_CSRNG_SW_APP_READ
                size: 1
                ismubi: true
                inv_default: 105
                desc:
                  '''
                  Enablement of CSRNG software application interface. A
                  kMultiBitBool8True value enables, while all other values
                  disable. Enablement is required to extract output from
                  CSRNG via software.
                  '''
                isdigest: false
                iszer: false
                iskeymgr_creator: false
                iskeymgr_owner: false
                absorb: false
                offset: 3649
              }
              {
                name: DIS_RV_DM_LATE_DEBUG
                size: 1
                ismubi: true
                inv_default: 105
                desc:
                  '''
                  Disablement of RV_DM late debug feature (see rv_dm
                  documentation). A kMultiBitBool8True disables the late debug
                  feature and renders the rv_dm fully ungated in DEV lifecycle
                  states. All other values gate rv_dm reachability based on
                  the value of LATE_DEBUG_ENABLE CSR in the rv_dm block.
                  '''
                isdigest: false
                iszer: false
                iskeymgr_creator: false
                iskeymgr_owner: false
                absorb: false
                offset: 3650
              }
              {
                name: HW_CFG1_DIGEST
                size: 8
                offset: 3656
                ismubi: false
                isdigest: true
                iszer: false
                inv_default: 13961193720981549769
                iskeymgr_creator: false
                iskeymgr_owner: false
              }
            ]
            desc:
              '''
              Hardware configuration 1 partition.
              This contains several hardware feature switches.
              '''
            absorb: false
            iskeymgr_creator: false
            iskeymgr_owner: false
            zeroizable: false
            ignore_read_lock_in_rma: false
            size: 16
            offset: 3648
          }
          {
            name: HW_CFG2
            variant: Buffered
            secret: false
            sw_digest: false
            hw_digest: true
            write_lock: Digest
            read_lock: None
            key_sel: NoKey
            integrity: true
            bkout_type: true
            zeroizable: true
            items:
            [
              {
                name: MANUF_STATE
                size: 32
                inv_default: 74703898927885615228644073031729127987260023218980427977577683364343954231749
                desc: Field to capture the manufacturing state.
                isdigest: false
                iszer: false
                ismubi: false
                iskeymgr_creator: false
                iskeymgr_owner: false
                absorb: false
                offset: 3664
              }
              {
                name: HW_CFG2_DIGEST
                size: 8
                offset: 3696
                ismubi: false
                isdigest: true
                iszer: false
                inv_default: 354744590412343289
                iskeymgr_creator: false
                iskeymgr_owner: false
              }
              {
                name: HW_CFG2_ZER
                size: 8
                offset: 3704
                ismubi: false
                isdigest: false
                iszer: true
                inv_default: 0
                iskeymgr_creator: false
                iskeymgr_owner: false
              }
            ]
            desc:
              '''
              Hardware configuration partition 2.
              This contains the manufacturing state.
              '''
            absorb: false
            iskeymgr_creator: false
            iskeymgr_owner: false
            ignore_read_lock_in_rma: false
            size: 48
            offset: 3664
          }
          {
            name: SECRET0
            variant: Buffered
            secret: true
            sw_digest: false
            hw_digest: true
            write_lock: Digest
            read_lock: Digest
            ignore_read_lock_in_rma: true
            key_sel: Secret0Key
            integrity: true
            bkout_type: false
            skip_sw_header: true
            items:
            [
              {
                name: TEST_UNLOCK_TOKEN
                inv_default: 230748029623541578864187550162391519735
                size: 16
                isdigest: false
                iszer: false
                ismubi: false
                iskeymgr_creator: false
                iskeymgr_owner: false
                absorb: false
                offset: 3712
              }
              {
                name: TEST_EXIT_TOKEN
                inv_default: 335469059873213918850882942343750995942
                size: 16
                isdigest: false
                iszer: false
                ismubi: false
                iskeymgr_creator: false
                iskeymgr_owner: false
                absorb: false
                offset: 3728
              }
              {
                name: SECRET0_DIGEST
                size: 8
                offset: 3744
                ismubi: false
                isdigest: true
                iszer: false
                inv_default: 15449436981428020477
                iskeymgr_creator: false
                iskeymgr_owner: false
              }
            ]
            desc:
              '''
              Secret partition 0.
              This contains TEST lifecycle unlock tokens.
              '''
            absorb: false
            iskeymgr_creator: false
            iskeymgr_owner: false
            zeroizable: false
            size: 40
            offset: 3712
          }
          {
            name: SECRET1
            variant: Buffered
            secret: true
            sw_digest: false
            hw_digest: true
            write_lock: Digest
            read_lock: Digest
            ignore_read_lock_in_rma: true
            key_sel: Secret1Key
            integrity: true
            bkout_type: false
            skip_sw_header: true
            items:
            [
              {
                name: FLASH_ADDR_KEY_SEED
                inv_default: 23531955425096136348941735642650773479001928178605645757494297030518339325231
                size: 32
                isdigest: false
                iszer: false
                ismubi: false
                iskeymgr_creator: false
                iskeymgr_owner: false
                absorb: false
                offset: 3752
              }
              {
                name: FLASH_DATA_KEY_SEED
                inv_default: 7536910898370239450524093328085871963862640062161248607096610222518662706945
                size: 32
                isdigest: false
                iszer: false
                ismubi: false
                iskeymgr_creator: false
                iskeymgr_owner: false
                absorb: false
                offset: 3784
              }
              {
                name: SRAM_DATA_KEY_SEED
                inv_default: 334671433878751700697199779069205613746
                size: 16
                isdigest: false
                iszer: false
                ismubi: false
                iskeymgr_creator: false
                iskeymgr_owner: false
                absorb: false
                offset: 3816
              }
              {
                name: SECRET1_DIGEST
                size: 8
                offset: 3832
                ismubi: false
                isdigest: true
                iszer: false
                inv_default: 16098215510217229036
                iskeymgr_creator: false
                iskeymgr_owner: false
              }
            ]
            desc:
              '''
              Secret partition 1.
              This contains SRAM and flash scrambling keys.
              '''
            absorb: false
            iskeymgr_creator: false
            iskeymgr_owner: false
            zeroizable: false
            size: 88
            offset: 3752
          }
          {
            name: SECRET2
            variant: Buffered
            secret: true
            sw_digest: false
            hw_digest: true
            write_lock: Digest
            read_lock: Digest
            ignore_read_lock_in_rma: true
            key_sel: Secret2Key
            integrity: true
            bkout_type: false
            skip_sw_header: true
            items:
            [
              {
                name: RMA_TOKEN
                inv_default: 130971651290035026448304299560793978178
                size: 16
                isdigest: false
                iszer: false
                ismubi: false
                iskeymgr_creator: false
                iskeymgr_owner: false
                absorb: false
                offset: 3840
              }
              {
                name: CREATOR_ROOT_KEY_SHARE0
                inv_default: 92348881548169349828605117641018822276568973017337749653532230513078504803567
                size: 32
                iskeymgr_creator: true
                isdigest: false
                iszer: false
                ismubi: false
                iskeymgr_owner: false
                absorb: false
                offset: 3856
              }
              {
                name: CREATOR_ROOT_KEY_SHARE1
                inv_default: 33599205987092681210239649990958622833804933314610392317109421837165274603539
                size: 32
                iskeymgr_creator: true
                isdigest: false
                iszer: false
                ismubi: false
                iskeymgr_owner: false
                absorb: false
                offset: 3888
              }
              {
                name: CREATOR_SEED
                inv_default: 42840131334136411941200644947425579008419079534194068434596656023607238656790
                size: 32
                iskeymgr_creator: true
                desc:
                  '''
                  Random seed value generated at manufacturing time for FIPS-compliance
                  when deriving the creator root keys during boot.
                  '''
                isdigest: false
                iszer: false
                ismubi: false
                iskeymgr_owner: false
                absorb: false
                offset: 3920
              }
              {
                name: SECRET2_DIGEST
                size: 8
                offset: 3952
                ismubi: false
                isdigest: true
                iszer: false
                inv_default: 14536313462089013680
                iskeymgr_creator: false
                iskeymgr_owner: false
              }
            ]
            desc:
              '''
              Secret partition 2.
              This contains RMA unlock token, creator root key, and creator seed.
              '''
            absorb: false
            iskeymgr_creator: true
            iskeymgr_owner: false
            zeroizable: false
            size: 120
            offset: 3840
          }
          {
            name: SECRET3
            variant: Buffered
            secret: true
            sw_digest: false
            hw_digest: true
            write_lock: Digest
            read_lock: Digest
            key_sel: Secret3Key
            integrity: true
            bkout_type: false
            zeroizable: true
            skip_sw_header: true
            items:
            [
              {
                name: OWNER_SEED
                inv_default: 46917961507141145256060626454085849401363337700765221407992884200406625985337
                size: 32
                iskeymgr_owner: true
                desc:
                  '''
                  Random seed value generated at manufacturing time for FIPS-compliance
                  when deriving the owner keys during boot.
                  '''
                isdigest: false
                iszer: false
                ismubi: false
                iskeymgr_creator: false
                absorb: false
                offset: 3960
              }
              {
                name: SECRET3_DIGEST
                size: 8
                offset: 3992
                ismubi: false
                isdigest: true
                iszer: false
                inv_default: 10535273937158094
                iskeymgr_creator: false
                iskeymgr_owner: false
              }
              {
                name: SECRET3_ZER
                size: 8
                offset: 4000
                ismubi: false
                isdigest: false
                iszer: true
                inv_default: 0
                iskeymgr_creator: false
                iskeymgr_owner: false
              }
            ]
            desc:
              '''
              Secret partition 3.
              This contains the owner intermediate and owner seeds.
              '''
            absorb: false
            iskeymgr_creator: false
            iskeymgr_owner: true
            ignore_read_lock_in_rma: false
            size: 48
            offset: 3960
          }
          {
            name: LIFE_CYCLE
            variant: LifeCycle
            secret: false
            sw_digest: false
            hw_digest: false
            write_lock: None
            read_lock: None
            key_sel: NoKey
            integrity: true
            bkout_type: false
            skip_sw_header: true
            items:
            [
              {
                name: LC_TRANSITION_CNT
                inv_default: 6707296131048348035660209850454458516403716907741954216822891807334833183171263528798563328586680206667318424192181
                size: 48
                isdigest: false
                iszer: false
                ismubi: false
                iskeymgr_creator: false
                iskeymgr_owner: false
                absorb: false
                offset: 4008
              }
              {
                name: LC_STATE
                inv_default: 150724158863578290761376796642879324047970044817803993230695865344826642621771004974996689303386
                size: 40
                isdigest: false
                iszer: false
                ismubi: false
                iskeymgr_creator: false
                iskeymgr_owner: false
                absorb: false
                offset: 4056
              }
            ]
            desc:
              '''
              Lifecycle partition.
              This contains lifecycle transition count and state. This partition
              cannot be locked since the life cycle state needs to advance to RMA
              in-field. Note that while this partition is not marked secret, it
              is not readable nor writeable via the DAI. Only the LC controller
              can access this partition, and even via the LC controller it is not
              possible to read the raw manufacturing life cycle state in encoded
              form, since that encoding is considered a netlist secret. The LC
              controller only exposes a decoded version of this state.
              '''
            absorb: false
            iskeymgr_creator: false
            iskeymgr_owner: false
            zeroizable: false
            ignore_read_lock_in_rma: false
            size: 88
            offset: 4008
          }
        ]
      }
    }
    {
      name: lc_ctrl
      type: lc_ctrl
      base_addrs:
      {
        regs:
        {
          hart: 0x40140000
        }
        dmi:
        {
          hart: 0x0
        }
      }
      memory: {}
      param_list:
      [
        {
          name: RndCnstLcKeymgrDivInvalid
          desc: Diversification value used for all invalid life cycle states.
          type: lc_ctrl_pkg::lc_keymgr_div_t
          randcount: 128
          randtype: data
          name_top: RndCnstLcCtrlLcKeymgrDivInvalid
          default: 0xf194ef96f3e535b58f2adad82b175fe9
          randwidth: 128
        }
        {
          name: RndCnstLcKeymgrDivTestUnlocked
          desc: Diversification value used for the TEST_UNLOCKED* life cycle states.
          type: lc_ctrl_pkg::lc_keymgr_div_t
          randcount: 128
          randtype: data
          name_top: RndCnstLcCtrlLcKeymgrDivTestUnlocked
          default: 0xea1c326a6610c1117744de61ccbfabd3
          randwidth: 128
        }
        {
          name: RndCnstLcKeymgrDivDev
          desc: Diversification value used for the DEV life cycle state.
          type: lc_ctrl_pkg::lc_keymgr_div_t
          randcount: 128
          randtype: data
          name_top: RndCnstLcCtrlLcKeymgrDivDev
          default: 0xe1fda667e04082478c14db070a6129bb
          randwidth: 128
        }
        {
          name: RndCnstLcKeymgrDivProduction
          desc: Diversification value used for the PROD/PROD_END life cycle states.
          type: lc_ctrl_pkg::lc_keymgr_div_t
          randcount: 128
          randtype: data
          name_top: RndCnstLcCtrlLcKeymgrDivProduction
          default: 0x2945b88dc6cfcf2ae02f47010cb666a5
          randwidth: 128
        }
        {
          name: RndCnstLcKeymgrDivRma
          desc: Diversification value used for the RMA life cycle state.
          type: lc_ctrl_pkg::lc_keymgr_div_t
          randcount: 128
          randtype: data
          name_top: RndCnstLcCtrlLcKeymgrDivRma
          default: 0xe22d3320f89caa47e5ced5d29cc9cdb4
          randwidth: 128
        }
        {
          name: RndCnstInvalidTokens
          desc: Compile-time random bits used for invalid tokens in the token mux
          type: lc_ctrl_pkg::lc_token_mux_t
          randcount: 1024
          randtype: data
          name_top: RndCnstLcCtrlInvalidTokens
          default: 0x68773ebacec14da34c505aedc70ea184c7a34193d59c735b5b4e2cbee5ab93cb024d6f8c0c700110cbf01425daf5141df19a882a71d66b5953dbc603379da9efb2069bd79815b2f8d99a40e7fdc4fb13143d7753ce1cf9e2029207396945c95c9b54bae6aef30d8577834ccc6caaa63a8e6604338151b9a23c08f9eed04ca1eb
          randwidth: 1024
        }
      ]
    }
    {
      name: alert_handler
      type: alert_handler
      base_addrs:
      {
        null:
        {
          hart: 0x40150000
        }
      }
      memory: {}
      param_list:
      [
        {
          name: RndCnstLfsrSeed
          desc: Compile-time random bits for initial LFSR seed
          type: alert_handler_pkg::lfsr_seed_t
          randcount: 32
          randtype: data
          name_top: RndCnstAlertHandlerLfsrSeed
          default: 0xb0bdd305
          randwidth: 32
        }
        {
          name: RndCnstLfsrPerm
          desc: Compile-time random permutation for LFSR output
          type: alert_handler_pkg::lfsr_perm_t
          randcount: 32
          randtype: perm
          name_top: RndCnstAlertHandlerLfsrPerm
          default: 0x950bd4ada63b8371e844d822f9b119af95c862df
          randwidth: 160
        }
      ]
      template_type: alert_handler
    }
    {
      name: sram_ctrl_ret_aon
      type: sram_ctrl
      base_addrs:
      {
        regs:
        {
          hart: 0x40500000
        }
        ram:
        {
          hart: 0x40600000
        }
      }
      memory:
      {
        ram:
        {
          label: ram_ret_aon
          swaccess: rw
          data_intg_passthru: True
          exec: True
          byte_write: True
          size: 0x1000
        }
      }
      param_list:
      [
        {
          name: RndCnstSramKey
          desc: Compile-time random reset value for SRAM scrambling key.
          type: otp_ctrl_pkg::sram_key_t
          randcount: 128
          randtype: data
          name_top: RndCnstSramCtrlRetAonSramKey
          default: 0xb594acddf170684f6ead2b7febfe8955
          randwidth: 128
        }
        {
          name: RndCnstSramNonce
          desc: Compile-time random reset value for SRAM scrambling nonce.
          type: otp_ctrl_pkg::sram_nonce_t
          randcount: 128
          randtype: data
          name_top: RndCnstSramCtrlRetAonSramNonce
          default: 0x23d7bc4846a485956c7f904b9eded09b
          randwidth: 128
        }
        {
          name: RndCnstLfsrSeed
          desc: Compile-time random bits for initial LFSR seed
          type: sram_ctrl_pkg::lfsr_seed_t
          randcount: 64
          randtype: data
          name_top: RndCnstSramCtrlRetAonLfsrSeed
          default: 0x89a75433566f4963
          randwidth: 64
        }
        {
          name: RndCnstLfsrPerm
          desc: Compile-time random permutation for LFSR output
          type: sram_ctrl_pkg::lfsr_perm_t
          randcount: 64
          randtype: perm
          name_top: RndCnstSramCtrlRetAonLfsrPerm
          default: 0x625f508cda39a480f25a750a4ed1520016fe2e233a6a65d913571dc5f3d1ad5cf43b08060a486ffea7aee07b3bf09df6
          randwidth: 384
        }
      ]
    }
    {
      name: flash_ctrl
      type: flash_ctrl
      base_addrs:
      {
        core:
        {
          hart: 0x41000000
        }
        mem:
        {
          hart: 0x20000000
        }
      }
      memory:
      {
        mem:
        {
          label: eflash
          swaccess: ro
          data_intg_passthru: True
          exec: True
          byte_write: False
          config:
          {
            banks: 2
            data_width: 64
            info_types: 3
            infos_per_bank:
            [
              10
              1
              2
            ]
            pages_per_bank: 256
            program_resolution: 8
            size: 0x100000
            words_per_page: 256
          }
          size: 0x100000
        }
      }
      param_list:
      [
        {
          name: RndCnstAddrKey
          desc: Compile-time random bits for default address key
          type: flash_ctrl_pkg::flash_key_t
          randcount: 128
          randtype: data
          name_top: RndCnstFlashCtrlAddrKey
          default: 0x6d60eda0f1bc67adf85bd9a56ea088d
          randwidth: 128
        }
        {
          name: RndCnstDataKey
          desc: Compile-time random bits for default data key
          type: flash_ctrl_pkg::flash_key_t
          randcount: 128
          randtype: data
          name_top: RndCnstFlashCtrlDataKey
          default: 0x33ffaa6a1155afb0169ab2de3973d027
          randwidth: 128
        }
        {
          name: RndCnstAllSeeds
          desc: Compile-time random bits for default seeds
          type: flash_ctrl_top_specific_pkg::all_seeds_t
          randcount: 512
          randtype: data
          name_top: RndCnstFlashCtrlAllSeeds
          default: 0xee30b8f901f644ec7cd3e56c8ed1ec38739f1d0deb7c774199cf6dd057f44c13e25c7a5877bc5242e6ee63ecdf458ae6596e87f9f973db98aaa293568fd1f31a
          randwidth: 512
        }
        {
          name: RndCnstLfsrSeed
          desc: Compile-time random bits for initial LFSR seed
          type: flash_ctrl_top_specific_pkg::lfsr_seed_t
          randcount: 32
          randtype: data
          name_top: RndCnstFlashCtrlLfsrSeed
          default: 0x165939d
          randwidth: 32
        }
        {
          name: RndCnstLfsrPerm
          desc: Compile-time random permutation for LFSR output
          type: flash_ctrl_top_specific_pkg::lfsr_perm_t
          randcount: 32
          randtype: perm
          name_top: RndCnstFlashCtrlLfsrPerm
          default: 0x79a3fbf3c506f1a3a564ed159ac9167302d18a70
          randwidth: 160
        }
      ]
      template_type: flash_ctrl
    }
    {
      name: acc
      type: acc
      base_addrs:
      {
        null:
        {
          hart: 0x41300000
        }
      }
      memory: {}
      param_list:
      [
        {
          name: RndCnstUrndPrngSeed
          desc: Default seed of the PRNG used for URND.
          type: acc_pkg::urnd_prng_seed_t
          randcount: 256
          randtype: data
          name_top: RndCnstAccUrndPrngSeed
          default: 0xd469171b950e364b0dac5469568e661498fd89197ccae8ea08ff43efc2bfb1c6
          randwidth: 256
        }
        {
          name: RndCnstAccKey
          desc: Compile-time random reset value for IMem/DMem scrambling key.
          type: otp_ctrl_pkg::acc_key_t
          randcount: 128
          randtype: data
          name_top: RndCnstAccAccKey
          default: 0xab5cc63e6f4741e80f777cb7fc05041a
          randwidth: 128
        }
        {
          name: RndCnstAccNonce
          desc: Compile-time random reset value for IMem/DMem scrambling nonce.
          type: otp_ctrl_pkg::acc_nonce_t
          randcount: 64
          randtype: data
          name_top: RndCnstAccAccNonce
          default: 0x1b896350c9636d68
          randwidth: 64
        }
      ]
    }
    {
      name: aes
      type: aes
      base_addrs:
      {
        null:
        {
          hart: 0x41100000
        }
      }
      memory: {}
      param_list:
      [
        {
          name: RndCnstClearingLfsrSeed
          desc: Default seed of the PRNG used for register clearing.
          type: aes_pkg::clearing_lfsr_seed_t
          randcount: 64
          randtype: data
          name_top: RndCnstAesClearingLfsrSeed
          default: 0x14d23e2f5ff1275e
          randwidth: 64
        }
        {
          name: RndCnstClearingLfsrPerm
          desc: Permutation applied to the LFSR of the PRNG used for clearing.
          type: aes_pkg::clearing_lfsr_perm_t
          randcount: 64
          randtype: perm
          name_top: RndCnstAesClearingLfsrPerm
          default: 0x7f2e317371580d7e4f89b0ba323ac494791d37d5104fb9d12f6f801ac809b8a688a4ec3466f7b3852575068b7fa969bc
          randwidth: 384
        }
        {
          name: RndCnstClearingSharePerm
          desc: Permutation applied to the clearing PRNG output for clearing the second share of registers.
          type: aes_pkg::clearing_lfsr_perm_t
          randcount: 64
          randtype: perm
          name_top: RndCnstAesClearingSharePerm
          default: 0x563918b756a10ee99fad95c939e0a858da9ccf194ac9ba4123c412ed11f7bcb3ff77a006f629f0f84d8ce39b05513834
          randwidth: 384
        }
        {
          name: RndCnstMaskingLfsrSeed
          desc: Default seed of the PRNG used for masking.
          type: aes_pkg::masking_lfsr_seed_t
          randcount: 288
          randtype: data
          name_top: RndCnstAesMaskingLfsrSeed
          default: 0x75ecc25d4e2267e3bff26e003aacbf7d513aea01e9ee420d5b523f6b00c81bded7282425
          randwidth: 288
        }
        {
          name: RndCnstMaskingLfsrPerm
          desc: Permutation applied to the output of the PRNG used for masking.
          type: aes_pkg::masking_lfsr_perm_t
          randcount: 160
          randtype: perm
          name_top: RndCnstAesMaskingLfsrPerm
          default: 0x1832345c0a52743b753d501944703f87919f691506435d2d8c8210268b042a280d472353677f420f86222e21649b58854d14111b4f4b3894788e9749245b1a1d548a655f160996602073992b001330464089774a6e7d68362c2f35335a0c6b9c571f934e664c417212450b179e6a8351927a079d318f026d803e27956f903c76037e62638d815629250e88397b611c7c5e716c0855059837849a3a791e480159
          randwidth: 1280
        }
      ]
    }
    {
      name: kmac
      type: kmac
      base_addrs:
      {
        null:
        {
          hart: 0x41120000
        }
      }
      memory: {}
      param_list:
      [
        {
          name: RndCnstLfsrSeed
          desc: Compile-time random data for PRNG default seed
          type: kmac_pkg::lfsr_seed_t
          randcount: 288
          randtype: data
          name_top: RndCnstKmacLfsrSeed
          default: 0x30ed9b18b90e42e4287f60ad57d6a551e78f940b8ae9f2bb40621f43f3abd8d737f8d12d
          randwidth: 288
        }
        {
          name: RndCnstLfsrPerm
          desc: Compile-time random permutation for PRNG output
          type: kmac_pkg::lfsr_perm_t
          randcount: 800
          randtype: perm
          name_top: RndCnstKmacLfsrPerm
          default: 0x6da998017028cc3259857614f0f9f75549f3227a3ba8e64c2f355c29aaaa3d515ae6110b1be078fa55ee584e7ca68de2804cb30067ed0271204751f16cd1f95c77b2afe769f42da42549f6015fc64a70576deb49c6acd96790fe38a7129d680724e271dcbe9ec5e5a898e31111408086b9f71a3047b5b2370ddeb8fa2d78a1f35c9eb993a7fe5545009aecf4360c0c767935068b5e3074e830a007778f13c2be18abd9b0d02b259badb883b1e7e16f36d977b9074f47e00d674d27e8a829005df5119a5c67fac4024fe931e0e7b062e0124941692268171caa5b567260a9b8e57886584b027b17c8b4255b990ca4d49851a50c65db402203364772a1a99a5b65312c7c25285e9375a93edbda554c995664485cbf123082e31b8eb441457cac812c144817c4746f568719d6ba705733a0ae6f1aa8161c18e1524e6068f0060d7d3a9ae8d965c39995ea2443c1143289265227e69cbbab837d878ce5a88b0638cf8a2b1b468aaa82ef8d4ed732742dead6d6d410d1e0eaab8054b37175499f30b6b08585a57c0c46314c1edf82a73701a7c55047e9016306d0c93794e17afeeda020805547bd49bba4cc6fdd2311fd8865f4a8352b4b0919e8ad07c78cb9861b47801d291505acff2c423ad4b2a9161bb17b958fd3969405af4c1658bf7186191c9b4f794b0b8a18109aafa083f4b86c2464f11d0a898f35ddcf1d88a640da4226b6dd62b61a23b2a3b0ea81763fc20d14b1a5a348431880358b39148c20ecdb4d4db7651252b2922c23991134b0419a61a10522743c8e1e11553123691a41561f485104ab039d61418e90cc9192ce841ce7352752686ab1c3b9c315fc2eadd3c6361272490c0c3006e777fadbb2716b2ed93c9728942745d5e99d0d5d2f788e688d30aa2285419efc3c70c464b4e65d07c606c2b611400566dca7ea980d295a6e16c58fc082a629132a65c7980a2a11b124cfb16f68b2a116db91a641b905842eff4658ba9d58091b2910191e5ba3862f3914175caf43954528571781208ac486f0918538824bf7a8fc82dd0bc148121360e62b4bc3d0ad212055c28846745a0a9af20ec889517e7960d16434be116878a5654730db0c209334a12b7d6d12557631ebc2f66e129ab5b80fb1c8e6bd9c316e00cc511ea064923b6865e71c8738130874924c8bba5eea674be196f932c40b424d544b5b5a29338422f00dc72aea1e9e852da58e7666cef54d60bc4d381e8c6266213f104fb13699ac9bd25085d56781a5aa9d9028b539e71359867e9664413041881a8d9602a2021421d63c0e08fc34972d23a150897c0c2b3ce98c8533e52d89e78bcddd9a4f65b6fb1d28fba16450dcb40c567b4a602dd96b5bb21a81b8ac64eda4c047f92b172e818139c5830b8931c8a620f19e3d
          randwidth: 8000
        }
        {
          name: RndCnstBufferLfsrSeed
          desc: Compile-time random data for PRNG buffer default seed
          type: kmac_pkg::buffer_lfsr_seed_t
          randcount: 800
          randtype: data
          name_top: RndCnstKmacBufferLfsrSeed
          default: 0xbd2c1319e71a293ac3249afc143e8770e304fee2d365da6c4a29010a99eaed073bcbd6e3eafa23f48eee34d31387b45b91ce49e4e6b587941d1eec356888ae5343dd784cba5bebbe2a6ead062d9516fdd8b110861a797cb684a3032ddac2da88d91cb185
          randwidth: 800
        }
        {
          name: RndCnstMsgPerm
          desc: Compile-time random permutation for LFSR Message output
          type: kmac_pkg::msg_perm_t
          randcount: 64
          randtype: perm
          name_top: RndCnstKmacMsgPerm
          default: 0x25169e2f243b3071a371ea1439ded4643a2c93fcf78160631bba057d1fe5089d210becad280999a3d96ab577c5f3adf
          randwidth: 384
        }
      ]
    }
    {
      name: keymgr
      type: keymgr
      base_addrs:
      {
        null:
        {
          hart: 0x41140000
        }
      }
      memory: {}
      param_list:
      [
        {
          name: RndCnstLfsrSeed
          desc: Compile-time random bits for initial LFSR seed
          type: keymgr_pkg::lfsr_seed_t
          randcount: 64
          randtype: data
          name_top: RndCnstKeymgrLfsrSeed
          default: 0xbcf7a82420750e5d
          randwidth: 64
        }
        {
          name: RndCnstLfsrPerm
          desc: Compile-time random permutation for LFSR output
          type: keymgr_pkg::lfsr_perm_t
          randcount: 64
          randtype: perm
          name_top: RndCnstKeymgrLfsrPerm
          default: 0x3826d36145b622b24113bdcb16a2b366d69589c1b9c3a8f1a26b0d0d19509e102efafc87f604a9d3c7dee0c764d4f5ff
          randwidth: 384
        }
        {
          name: RndCnstRandPerm
          desc: Compile-time random permutation for entropy used in share overriding
          type: keymgr_pkg::rand_perm_t
          randcount: 32
          randtype: perm
          name_top: RndCnstKeymgrRandPerm
          default: 0x6a7171bf59a089f344303ae48e31c5eaad59f81b
          randwidth: 160
        }
        {
          name: RndCnstRevisionSeed
          desc: Compile-time random bits for revision seed
          type: keymgr_pkg::seed_t
          randcount: 256
          randtype: data
          name_top: RndCnstKeymgrRevisionSeed
          default: 0x31bbc9a8c73fc4cc3d14ca6bc0b96812de7c775a54ff19343cb32040b3490768
          randwidth: 256
        }
        {
          name: RndCnstCreatorIdentitySeed
          desc: Compile-time random bits for creator identity seed
          type: keymgr_pkg::seed_t
          randcount: 256
          randtype: data
          name_top: RndCnstKeymgrCreatorIdentitySeed
          default: 0x889d27e0ba8588d34c05bcf127dae58b65d6a251088099b37107b1cccf1a955f
          randwidth: 256
        }
        {
          name: RndCnstOwnerIntIdentitySeed
          desc: Compile-time random bits for owner intermediate identity seed
          type: keymgr_pkg::seed_t
          randcount: 256
          randtype: data
          name_top: RndCnstKeymgrOwnerIntIdentitySeed
          default: 0x3de1a8447bf83b69c50e149cf51784a9d7ac691306e5c56ce38cd7d7e3b1abf
          randwidth: 256
        }
        {
          name: RndCnstOwnerIdentitySeed
          desc: Compile-time random bits for owner identity seed
          type: keymgr_pkg::seed_t
          randcount: 256
          randtype: data
          name_top: RndCnstKeymgrOwnerIdentitySeed
          default: 0xb7978189a21ae856f1d908e3f70de343d2226e9e864465a8ee55ec0e6a296789
          randwidth: 256
        }
        {
          name: RndCnstSoftOutputSeed
          desc: Compile-time random bits for software generation seed
          type: keymgr_pkg::seed_t
          randcount: 256
          randtype: data
          name_top: RndCnstKeymgrSoftOutputSeed
          default: 0xded5c0af59ee62f1fd1bbebeac2205b1fa5e94e72eb7eb1a713ad15d2565d9ab
          randwidth: 256
        }
        {
          name: RndCnstHardOutputSeed
          desc: Compile-time random bits for hardware generation seed
          type: keymgr_pkg::seed_t
          randcount: 256
          randtype: data
          name_top: RndCnstKeymgrHardOutputSeed
          default: 0x4fbcd2e17c406f48d1401f8a6a52286f6954c27a9aefbe0bc9ee440c514ccacb
          randwidth: 256
        }
        {
          name: RndCnstAesSeed
          desc: Compile-time random bits for generation seed when aes destination selected
          type: keymgr_pkg::seed_t
          randcount: 256
          randtype: data
          name_top: RndCnstKeymgrAesSeed
          default: 0x19995f31fa958859293c5591ae604a92a303760eb8d7785a7bbdce1d6a02b6f
          randwidth: 256
        }
        {
          name: RndCnstKmacSeed
          desc: Compile-time random bits for generation seed when kmac destination selected
          type: keymgr_pkg::seed_t
          randcount: 256
          randtype: data
          name_top: RndCnstKeymgrKmacSeed
          default: 0xf24f5db8ef02f9fb0a4023d8f96a41f062bb66b228701e8317cd4bf08bd6684
          randwidth: 256
        }
        {
          name: RndCnstAccSeed
          desc: Compile-time random bits for generation seed when acc destination selected
          type: keymgr_pkg::seed_t
          randcount: 256
          randtype: data
          name_top: RndCnstKeymgrAccSeed
          default: 0xa1d596cc57e137a0321fb803bfd2de7a90a1357e743ce460442c10686e82613d
          randwidth: 256
        }
        {
          name: RndCnstCdi
          desc: Compile-time random bits for generation seed when no CDI is selected
          type: keymgr_pkg::seed_t
          randcount: 256
          randtype: data
          name_top: RndCnstKeymgrCdi
          default: 0xe0806dde1d35ad6160ee7ef48222dad72d4d6289edd5f001dcd4095890a290a9
          randwidth: 256
        }
        {
          name: RndCnstNoneSeed
          desc: Compile-time random bits for generation seed when no destination selected
          type: keymgr_pkg::seed_t
          randcount: 256
          randtype: data
          name_top: RndCnstKeymgrNoneSeed
          default: 0xb632f0395d11cac7f7e9e764add7ede232a4e00dabf1d1d2ad2e2a5133f6a12f
          randwidth: 256
        }
      ]
    }
    {
      name: csrng
      type: csrng
      base_addrs:
      {
        null:
        {
          hart: 0x41150000
        }
      }
      memory: {}
      param_list:
      [
        {
          name: RndCnstCsKeymgrDivNonProduction
          desc: Compile-time random bits for csrng state group diversification value
          type: csrng_pkg::cs_keymgr_div_t
          randcount: 384
          randtype: data
          name_top: RndCnstCsrngCsKeymgrDivNonProduction
          default: 0xf2ec1569bef1f0b924c470ac5a99809985dc415ba1eaced382d54c9e378d030ea5d37665d43a035f4ea1e463032a3a8e
          randwidth: 384
        }
        {
          name: RndCnstCsKeymgrDivProduction
          desc: Compile-time random bits for csrng state group diversification value
          type: csrng_pkg::cs_keymgr_div_t
          randcount: 384
          randtype: data
          name_top: RndCnstCsrngCsKeymgrDivProduction
          default: 0x24b4547f8b0db0c77e902776b104c3a9da02030621a4d3d73871fdaf5ad0c1dd1e95f99d7129ca6861a4425b9cc42edb
          randwidth: 384
        }
      ]
    }
    {
      name: sram_ctrl_main
      type: sram_ctrl
      base_addrs:
      {
        regs:
        {
          hart: 0x411C0000
        }
        ram:
        {
          hart: 0x10000000
        }
      }
      memory:
      {
        ram:
        {
          label: ram_main
          swaccess: rw
          data_intg_passthru: True
          exec: True
          byte_write: True
          size: 0x20000
        }
      }
      param_list:
      [
        {
          name: RndCnstSramKey
          desc: Compile-time random reset value for SRAM scrambling key.
          type: otp_ctrl_pkg::sram_key_t
          randcount: 128
          randtype: data
          name_top: RndCnstSramCtrlMainSramKey
          default: 0xa88a15b752539fb8e598f891c2bd3162
          randwidth: 128
        }
        {
          name: RndCnstSramNonce
          desc: Compile-time random reset value for SRAM scrambling nonce.
          type: otp_ctrl_pkg::sram_nonce_t
          randcount: 128
          randtype: data
          name_top: RndCnstSramCtrlMainSramNonce
          default: 0x77126ea6934d3749740a7ce7c92a49f7
          randwidth: 128
        }
        {
          name: RndCnstLfsrSeed
          desc: Compile-time random bits for initial LFSR seed
          type: sram_ctrl_pkg::lfsr_seed_t
          randcount: 64
          randtype: data
          name_top: RndCnstSramCtrlMainLfsrSeed
          default: 0x1747d5a7e3b7e444
          randwidth: 64
        }
        {
          name: RndCnstLfsrPerm
          desc: Compile-time random permutation for LFSR output
          type: sram_ctrl_pkg::lfsr_perm_t
          randcount: 64
          randtype: perm
          name_top: RndCnstSramCtrlMainLfsrPerm
          default: 0x5d24753ff8da0d8b30c721eb59477db77d2893b2c841f34cd858957ba1af05b9be9594e0b840b9cf8f0986a027a4e29c
          randwidth: 384
        }
      ]
    }
    {
      name: rom_ctrl
      type: rom_ctrl
      base_addrs:
      {
        rom:
        {
          hart: 0x00008000
        }
        regs:
        {
          hart: 0x411e0000
        }
      }
      memory:
      {
        rom:
        {
          label: rom
          swaccess: ro
          data_intg_passthru: True
          exec: True
          byte_write: False
          size: 0x8000
        }
      }
      param_list:
      [
        {
          name: RndCnstScrNonce
          desc: Fixed nonce used for address / data scrambling
          type: bit [63:0]
          randcount: 64
          randtype: data
          name_top: RndCnstRomCtrlScrNonce
          default: 0xade12af0dd48b922
          randwidth: 64
        }
        {
          name: RndCnstScrKey
          desc: Randomised constant used as a scrambling key for ROM data
          type: bit [127:0]
          randcount: 128
          randtype: data
          name_top: RndCnstRomCtrlScrKey
          default: 0x7a978179aa2e6adc5ea5fd83777d3877
          randwidth: 128
        }
      ]
    }
    {
      name: rv_core_ibex
      type: rv_core_ibex
      base_addrs:
      {
        cfg:
        {
          hart: 0x411F0000
        }
      }
      memory: {}
      param_list:
      [
        {
          name: RndCnstLfsrSeed
          desc: Default seed of the PRNG used for random instructions.
          type: ibex_pkg::lfsr_seed_t
          randcount: 32
          randtype: data
          name_top: RndCnstRvCoreIbexLfsrSeed
          default: 0x66ba9e8c
          randwidth: 32
        }
        {
          name: RndCnstLfsrPerm
          desc: Permutation applied to the LFSR of the PRNG used for random instructions.
          type: ibex_pkg::lfsr_perm_t
          randcount: 32
          randtype: perm
          name_top: RndCnstRvCoreIbexLfsrPerm
          default: 0x65b0dbf4a08a15a984f221b79f3e1fe24551ae8e
          randwidth: 160
        }
        {
          name: RndCnstIbexKeyDefault
          desc: Default icache scrambling key
          type: logic [ibex_pkg::SCRAMBLE_KEY_W-1:0]
          randcount: 128
          randtype: data
          name_top: RndCnstRvCoreIbexIbexKeyDefault
          default: 0x9da8413dda43fecdd6c1a58693232d1c
          randwidth: 128
        }
        {
          name: RndCnstIbexNonceDefault
          desc: Default icache scrambling nonce
          type: logic [ibex_pkg::SCRAMBLE_NONCE_W-1:0]
          randcount: 64
          randtype: data
          name_top: RndCnstRvCoreIbexIbexNonceDefault
          default: 0x3e361d856ab2d1dc
          randwidth: 64
        }
      ]
      template_type: rv_core_ibex
    }
  ]
}
