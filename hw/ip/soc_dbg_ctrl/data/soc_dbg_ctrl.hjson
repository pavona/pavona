// Copyright lowRISC contributors (OpenTitan project).
// Copyright zeroRISC Inc.
// Licensed under the Apache License, Version 2.0, see LICENSE for details.
// SPDX-License-Identifier: Apache-2.0

{
  name:               "soc_dbg_ctrl",
  human_name:         "SoC Debug Access Control Module",
  one_line_desc:      "Control module to enable or disable debug access",
  one_paragraph_desc: '''
  Module that controls the Debug / DFT access feature for an SoC for which Pavona serves as an integrated HW RoT.
  A debug policy bus driven from this module governs the unlock policy. Output from the debug policy bus is decoded by various debug / DFT logic blocks in an SoC to determine if the debug / DFT access feature is allowed or not.
  The access policy is derived by the RoT with a challenge-response based debug authentication exchange session with a remote policy enforcer.
  '''
  // Unique comportable IP identifier defined under KNOWN_CIP_IDS in the regtool.
  cip_id:             "42",
  design_spec:        "../doc",
  dv_doc:             "../doc/dv",
  hw_checklist:       "../doc/checklist",
  sw_checklist:       "/sw/ip/soc_dbg_ctrl/dif/dif_soc_dbg_ctrl",
  revisions: [
    {
      version:            "1.0.0",
      life_stage:         "L1",
      design_stage:       "D1",
      verification_stage: "V1",
      dif_stage:          "S1",
      notes:              ""
    }
  ]

  clocking: [{clock: "clk_i", reset: "rst_ni"}],

  bus_interfaces: [
    { protocol: "tlul", direction: "device", name: "core" }
    { protocol: "tlul", direction: "device", name: "jtag" }
  ]

  alert_list: [
    { name: "fatal_fault",
      desc: "This fatal alert is triggered when a fatal TL-UL bus integrity fault is detected."
    }
    { name: "recov_ctrl_update_err",
      desc: '''
        This recoverable alert is triggered upon detecting an update error in the shadowed Control Register.
      '''
    }
  ]

  features: [
    // Debug policy generation
    {
      name: "SOC_DBG_CTRL.POLICY.SW_PROGRAMMABLE"
      desc: '''
            The firmware can program the broadcast debug category through the `DEBUG_POLICY_CATEGORY_SHADOWED`
            CSR. Its written value reaches the output bus only during the `SocDbgStProd` lifecycle state,
            when not in RMA state and with the CPU running.
            '''
    }
    {
      name: "SOC_DBG_CTRL.POLICY.LC_RMA_OVERRIDE"
      desc: '''
            During the `SocDbgStProd` state, the RMA state (if strictly true) will override the
            software-assigned category and set the policy to Category 4.
            '''
    }
    {
      name: "SOC_DBG_CTRL.POLICY.LC_BLANK_OVERRIDE"
      desc: '''
            For the `SocDbgStBlank` state, the policy will be 'locked' unless:
            - DFT is enabled by the lifecycle controller
            - Hardware debug is enabled by the lifecycle controller
            In which case, it will broadcast a Category 4 policy, with no software override.
            '''
    }
    {
      name: "SOC_DBG_CTRL.POLICY.LC_PREPROD_OVERRIDE"
      desc: '''
            For the `SocDbgStPreProd` lifecycle controller state, the broadcast policy
            is always set to Category 4, with no software override.
            '''
    }
    {
      name: "SOC_DBG_CTRL.POLICY.RELOCK_REUNLOCK"
      desc: '''
            Firmware may set `DEBUG_POLICY_RELOCKED` to indicate that the debugger has
            relocked the part. This `relocked` field is broadcast in the policy bus alongside
            `category` and `valid`. This capability is only allowed for the `SocDbgStProd` state,
            when not in RMA and with the CPU running.
            '''
    }
    // Tracing of CSRs
    {
      name: "SOC_DBG_CTRL.TRACE.CORE_POLICY_READBACK"
      desc: '''
            The live broadcast debug policy (`category`, `valid`, `relocked`) is continuously
            reflected to RoT firmware through the read-only `TRACE_DEBUG_POLICY_CATEGORY` and
            `TRACE_DEBUG_POLICY_VALID_RELOCKED` CSRs on the core TL-UL interface.
            '''
    }
    {
      name: "SOC_DBG_CTRL.TRACE.JTAG_POLICY_READBACK"
      desc: '''
            The live broadcast debug policy (`category`, `valid`, `relocked`) is reflected to the
            external debugger through the read-only `JTAG_TRACE_DEBUG_POLICY_CATEGORY` and
            `JTAG_TRACE_DEBUG_POLICY_VALID_RELOCKED` CSRs on the JTAG TL-UL interface.
            '''
    }
    {
      name: "SOC_DBG_CTRL.TRACE.JTAG_BOOT_STATUS_GATED_BY_DFT"
      desc: '''
            The `JTAG_BOOT_STATUS` and `JTAG_TRACE_SOC_DBG_STATE` CSRs will only reflect the
            hardware state when `lc_dft_en` is strictly true. Otherwise, all the fields will
            read as zero.
            '''
    }
    {
      name: "SOC_DBG_CTRL.TRACE.AUTH_PROGRESS_MIRRORING"
      desc: '''
            The Root-of-Trust firmware reports the state of the debug authorization exchange in the
            core-side `STATUS` CSR. This same CSR is mirrored through the `JTAG_STATUS` CSR, which
            is surfaced so the external debugger can read the authorization progress.
            '''
    }
    // Ibex halting
    { name: "SOC_DBG_CTRL.HALT.FSM",
      desc: '''
            A sparse-encoded FSM sequences the early-boot halt decision based on:
            - Whether the current lifecycle state is RMA
            - Whether DFT debug is enabled by LC as a result of Volatile Raw Unlock
            - Whether the external `halt_cpu_boot_i` pin is asserted
            - Whether the JTAG command to stop the boot flow is asserted

            The FSM has a single terminal state such that once the halt is released,
            Ibex cannot be re-halted without reset.
            '''
    }
    { name: "SOC_DBG_CTRL.HALT.PRODUCTION_PASSTHROUGH",
      desc: '''
            In lifecycle states that are not RMA, the halt FSM bypasses the halt path,
            releasing Ibex unconditionally. The halt mechanism is therefore unreachable on production
            parts: neither the `halt_cpu_boot` pin nor JTAG_CONTROL can wedge boot.
            '''
    }
  ]

  countermeasures: [
    { name: "BUS.INTEGRITY",
      desc: "End-to-end bus integrity scheme.",
    }
    { name: "DEBUG_POLICY_VALID.CONFIG.SHADOW",
      desc: "Debug policy valid register is shadowed."
    }
    { name: "DEBUG_POLICY_CATEGORY.CONFIG.SHADOW",
      desc: "Debug policy category register is shadowed."
    }
    { name: "HALT.FSM.SPARSE",
      desc: "The halt FSM uses a sparse state encoding."
    }
  ]

  inter_signal_list: [
    { struct:  "pwr_boot_status",
      type:    "uni",
      name:    "boot_status",
      act:     "rcv",
      package: "pwrmgr_pkg",
    },
    { struct:  "soc_dbg_state"
      type:    "uni"
      name:    "soc_dbg_state"
      package: "lc_ctrl_state_pkg"
      act:     "rcv"
    }
    { struct:  "soc_dbg_policy"
      type:    "uni"
      name:    "soc_dbg_policy_bus"
      package: "soc_dbg_ctrl_pkg"
      act:     "req"
    }
    { struct:  "lc_tx"
      type:    "uni"
      name:    "lc_hw_debug_en"
      act:     "rcv"
      default: "lc_ctrl_pkg::Off"
      package: "lc_ctrl_pkg"
      desc:    "Multibit life cycle hardware debug enable signal coming from life cycle controller, asserted when the hardware debug mechanisms are enabled in the system."
    },
    { struct:  "lc_tx"
      type:    "uni"
      name:    "lc_dft_en"
      act:     "rcv"
      default: "lc_ctrl_pkg::Off"
      package: "lc_ctrl_pkg"
      desc:    '''
               Test enable qualifier coming from life cycle controller.
               This signals enables TEST & RMA mode accesses.
               '''
    }
    { struct:  "lc_tx"
      type:    "uni"
      name:    "lc_raw_test_rma"
      act:     "rcv"
      default: "lc_ctrl_pkg::Off"
      package: "lc_ctrl_pkg"
      desc:    '''
               Test enable qualifier coming from life cycle controller.
               This signals enables RAW, TEST and RMA mode accesses.
               '''
    }
    { struct:  "lc_tx"
      type:    "uni"
      name:    "lc_cpu_en"
      act:     "rcv"
      default: "lc_ctrl_pkg::Off"
      package: "lc_ctrl_pkg"
      desc:    '''
               CPU enable qualifier coming from life cycle controller.
               Indication from life cycle controller that the CPU is running.
               '''
    }
    { struct:  "lc_tx"
      type:    "uni"
      name:    "lc_rma_state"
      act:     "rcv"
      default: "lc_ctrl_pkg::Off"
      package: "lc_ctrl_pkg"
      desc:    '''
               RMA state qualifier coming from life cycle controller.
               Indication from life cycle controller that the RMA state is active.
               '''
    }
    { struct:  'logic'
      type:    'uni'
      name:    'halt_cpu_boot'
      act:     'rcv'
      desc:    "External request to halt the CPU until a JTAG command allows the boot process to continue."
    }
    { struct:  'pwrmgr_data'
      type:    'uni'
      name:    'continue_cpu_boot'
      package: 'rom_ctrl_pkg'
      act:     'req'
      desc:    '''
               Artificial ROM control input to the pwrmgr to halt the boot process.
               '''
    }
  ]

  regwidth: "32"
  registers: {
    core: [
      { name: "DEBUG_POLICY_VALID_SHADOWED"
        desc: '''
              Debug Policy Valid.
              The debug policy category can only be written while this register holds Mubi4::False.
              Any other value, including an invalid encoding, locks the category.
              In the production debug state, with the CPU enabled and outside of RMA, the value of
              this register is broadcast as the valid field of the debug policy.
              '''
        swaccess: "rw1s"
        hwaccess: "hro"
        shadowed: "true"
        update_err_alert: "recov_ctrl_update_err",
        storage_err_alert: "fatal_fault",
        tags: [
          // Writting to this register will gate by the debug_policy_category_shadowed register.
          // So excluded from CSR automation test.
          "excl:CsrNonInitTests:CsrExclWrite"
        ]
        fields: [
          { bits: "3:0"
            mubi: true
            resval: false
            name: "debug_policy_valid"
            desc: '''
                  Indicates the validity of the debug policy output.
                  '''
          }
        ]
      }
      { name: "DEBUG_POLICY_CATEGORY_SHADOWED"
        desc: "Debug Policy category"
        swaccess: "rw"
        hwaccess: "hrw"
        hwqe: true
        hwre: true
        hwext: true
        shadowed: "true"
        update_err_alert: "recov_ctrl_update_err",
        storage_err_alert: "fatal_fault",
        fields: [
          { bits: "6:0"
            resval: "0x50"
            name: "debug_policy_category"
            desc: '''
                  Debug Policy Control Setting.
                  Indicates the current debug authorization policy that is distributed to the rest of the SoC to govern debug / DFT feature unlock.
                  '''
            tags: ["shadowed_reg_path:u_debug_policy_category_shadowed"]
          }
        ]
      }
      { name: "DEBUG_POLICY_RELOCKED"
        desc: "Debug Policy relocked"
        swaccess: "rw"
        hwaccess: "hro"
        fields: [
          { bits: "3:0"
            mubi: true
            resval: false
            name: "debug_policy_relocked"
            desc: '''
                  The relocked state.
                  '''
          }
        ]
      }
      { name: "TRACE_DEBUG_POLICY_CATEGORY"
        desc: "Trace register to observe the debug category that is determined either by hardware or by software."
        swaccess: "ro"
        hwaccess: "hwo"
        fields: [
          { bits: "6:0"
            resval: "0x50"
            name: "category"
            desc: '''
                  The debug policy determined by hardware or software.
                  '''
          }
        ]
      }
      { name: "TRACE_DEBUG_POLICY_VALID_RELOCKED"
        desc: "Trace register to observe the valid or relocked state that is determined either by hardware or by software."
        swaccess: "ro"
        hwaccess: "hwo"
        fields: [
          { bits: "7:4"
            mubi: true
            resval: false
            name: "relocked"
            desc: '''
                  The relocked state determined by hardware or software.
                  '''
          }
          { bits: "3:0"
            mubi: true
            resval: false
            name: "valid"
            desc: '''
                  The valid state determined by hardware or software.
                  '''
          }
        ]
      }
      { name:     "STATUS"
        desc:     "Debug Status Register"
        swaccess: "rw"
        hwaccess: "hro"
        fields: [
          { bits: "0"
            name: "auth_debug_intent_set"
            desc: '''
                  Status bit indicating whether the debug intent hardware strap was set.
                  If set, SoC will be treated as under debug, and authorized debug can be enabled to unlock the SoC at the desired debug unlock level.
                  '''
            resval: "0"
          }
          { bits: "4"
            name: "auth_window_open"
            desc: '''
                  Status bit that tells whether debug authorization exchange can take place.
                  This bit is set when auth_debug_intent_set is 1, and the SoC reset sequence is paused to enable debug authorization exchange.
                  '''
            resval: "0"
          }
          { bits: "5"
            name: "auth_window_closed"
            desc: '''
                  Status bit that indicates that SoC reset sequence is unpaused.
                  SoC shall continue to boot and the debug authorization exchange cannot take place anymore until the next reset.
                  Note that the rest of the SoC reset sequence is triggered by the OT RoT.
                  '''
            resval: "0"
          }
          { bits: "6"
            name: "auth_unlock_success"
            desc: "Status bit indicating whether the unlock protocol resulted in a successful unlock at the requested level."
            resval: "0"
          }
          { bits: "7"
            name: "auth_unlock_failed"
            desc: "Status bit indicating whether the unlock protocol resulted in unlock failure at the requested level."
            resval: "0"
          }
        ]
      }
    ]
    jtag: [
      { name: "JTAG_TRACE_DEBUG_POLICY_CATEGORY"
        desc: "Trace register to observe the debug category that is determined either by hardware or by software."
        swaccess: "ro"
        hwaccess: "hwo"
        fields: [
          { bits: "6:0"
            resval: "0x50"
            name: "category"
            desc: '''
                  The debug policy determined by hardware or software.
                  '''
          }
        ]
      }
      { name: "JTAG_TRACE_DEBUG_POLICY_VALID_RELOCKED"
        desc: "Trace register to observe the valid or relocked state that is determined either by hardware or by software."
        swaccess: "ro"
        hwaccess: "hwo"
        fields: [
          { bits: "7:4"
            mubi: true
            resval: false
            name: "relocked"
            desc: '''
                  The relocked state determined by hardware or software.
                  '''
          }
          { bits: "3:0"
            mubi: true
            resval: false
            name: "valid"
            desc: '''
                  The valid state determined by hardware or software.
                  '''
          }
        ]
      }
      { name: "JTAG_CONTROL"
        desc: "JTAG control register to interact with the boot flow."
        swaccess: "rw"
        hwaccess: "hro"
        fields: [
          { bits: "0"
            resval: "0"
            name: "boot_continue"
            desc: '''
                  JTAG bit to stop or continue the boot flow of Ibex.
                    1'b0: Stop and halt boot flow.
                    1'b1: Continue with the boot flow and let Ibex fetch code.
                  '''
          }
        ]
      }
      { name:     "JTAG_STATUS"
        desc:     "Debug Status Register"
        swaccess: "ro"
        hwaccess: "hwo"
        hwext:    "true"
        tags: [
          // The status register is written by IBEX firmware and is reflected into the JTAG status register.
          // So excluded from CSR automation test.
          "excl:CsrNonInitTests:CsrExclWriteCheck"
        ]
        fields: [
          { bits: "0"
            name: "auth_debug_intent_set"
            desc: '''
                  Status bit indicating whether the debug intent hardware strap was set.
                  If set, SoC will be treated as under debug, and authorized debug can be enabled to unlock the SoC at the desired debug unlock level.
                  '''
            resval: "0"
          }
          { bits: "4"
            name: "auth_window_open"
            desc: '''
                  Status bit that tells whether debug authorization exchange can take place.
                  This bit is set when auth_debug_intent_set is 1, and the SoC reset sequence is paused to enable debug authorization exchange.
                  '''
            resval: "0"
          }
          { bits: "5"
            name: "auth_window_closed"
            desc: '''
                  Status bit that indicates that SoC reset sequence is unpaused.
                  SoC shall continue to boot and the debug authorization exchange cannot take place anymore until the next reset.
                  Note that the rest of the SoC reset sequence is triggered by the OT RoT.
                  '''
            resval: "0"
          }
          { bits: "6"
            name: "auth_unlock_success"
            desc: "Status bit indicating whether the unlock protocol resulted in a successful unlock at the requested level"
            resval: "0"
          }
          { bits: "7"
            name: "auth_unlock_failed"
            desc: "Status bit indicating whether the unlock protocol resulted in unlock failure at the requested level"
            resval: "0"
          }
        ]
      }
      { name: "JTAG_BOOT_STATUS"
        desc: '''
              Debug boot status register that tells important boot state information.
              Note that this information is reflected only if the hw_dft_en signal is true.
              '''
        swaccess: "ro"
        hwaccess: "hwo"
        hwext:    "true"
        fields: [
          { bits: "0"
            name: "main_clk_status"
            desc: '''
                  Status of the main clock activation.
                  '''
            resval: "0"
          }
          { bits: "1"
            name: "io_clk_status"
            desc: '''
                  Status of the IO Clock activation.
                  '''
            resval: "0"
          }
          { bits: "2"
            name: "otp_done"
            desc: '''
                  OTP controller initialization complete.
                  '''
            resval: "0"
          }
          { bits: "3"
            name: "lc_done"
            desc: '''
                  Lifecycle controller initialization done; LC policy is decoded and set.
                  '''
            resval: "0"
          }
          { bits: "4"
            name: "cpu_fetch_en"
            desc: '''
                  Indication from power manager to IBEX to start code execution
                  '''
            resval: "0"
          }
          { bits: "10:5"
            name: "halt_fsm_state"
            desc: '''
                  The state of the halt FSM.
                  '''
            resval: "0"
          }
          { bits: "13:11"
            name: "boot_greenlight_done"
            desc: '''
                  Green lights for the boot process: _done_ indication coming from
                    [0]: base ROM
                    [1]: second ROM
                    [2]: this module

                  Note that for the boot process to go through, all _done_ bits in this field and all _good_ bits in the next field need to be set.
                  '''
            resval: "0"
          }
          { bits: "16:14"
            name: "boot_greenlight_good"
            desc: '''
                  Green lights status for the boot process: _good_ indication coming from
                    [0]: base ROM
                    [1]: second ROM
                    [2]: this module
                  '''
            resval: "0"
          }
        ]
      }
      { name: "JTAG_TRACE_SOC_DBG_STATE"
        desc: '''
              Reports the current debug state coming from OTP.
              Note that this information is reflected only if the hw_dft_en signal is true.
              '''
        swaccess: "ro"
        hwaccess: "hwo"
        hwext:    "true"
        fields: [
          { bits: "31:0"
            name: "soc_dbg_state"
            desc: '''
                  The current debug state.
                  '''
            resval: "0"
          }
        ]
      }
    ]
  }
}
