// Copyright lowRISC contributors (OpenTitan project).
// Licensed under the Apache License, Version 2.0, see LICENSE for details.
// SPDX-License-Identifier: Apache-2.0
{ name:               "entropy_src",
  human_name:         "Entropy Source",
  one_line_desc:      "Filters and checks raw entropy bits from a random noise source and forwards them to CSRNG",
  one_paragraph_desc: '''
  Entropy Source takes bits from a physically random noise source (external to Entropy Source) and produces random values in a manner that is compliant both with FIPS (through [NIST SP 800-90B][nist-sp-800-90b]) and [CC (AIS31)][bsi-ais31] recommendations.
  The random values produced by Entropy Source serve as non-deterministic seeds for CSRNG.
  Depending on the mode of operation, Entropy Source can apply a secure hash function to the raw noise bits for conditioning.
  To detect statistical defects in the raw noise bits, Entropy Source performs multiple health checks.

  [bsi-ais31]: https://www.bsi.bund.de/SharedDocs/Downloads/DE/BSI/Zertifizierung/Interpretationen/AIS_31_Functionality_classes_for_random_number_generators_e.pdf
  [nist-sp-800-90b]: https://nvlpubs.nist.gov/nistpubs/SpecialPublications/NIST.SP.800-90B.pdf
  '''
  // Unique comportable IP identifier defined under KNOWN_CIP_IDS in the regtool.
  cip_id:             "7",
  design_spec:        "../doc",
  dv_doc:             "../doc/dv",
  hw_checklist:       "../doc/checklist",
  sw_checklist:       "/sw/device/lib/dif/dif_entropy_src",
  version:            "3.0.0",
  life_stage:         "L1",
  design_stage:       "D2S",
  verification_stage: "V2S",
  dif_stage:          "S2",
  clocking: [{clock: "clk_i", reset: "rst_ni"}],
  bus_interfaces: [
    { protocol: "tlul", direction: "device" }
  ],
  interrupt_list: [
    { name: "es_entropy_valid"
      desc: "Asserted when entropy source bits are available for firmware for consumption via !!ENTROPY_DATA register."}
    { name: "es_health_test_failed"
      desc: "Asserted whenever the main state machine is in the alert state, e.g., due to health tests failing and reaching the threshold value configured in !!ALERT_THRESHOLD."}
    { name: "es_observe_fifo_ready"
      desc: "Asserted when the observe FIFO has filled to the configured threshold level (see !!OBSERVE_FIFO_THRESH)."}
    { name: "es_fatal_err"
      desc: "Asserted when an fatal error condition is met, e.g., upon FIFO errors, or if an illegal state machine state is reached."}
  ],
  inter_signal_list: [
    { struct:  "entropy_src_hw_if",
      type:    "req_rsp",
      name:    "entropy_src_hw_if",
      act:     "rsp",
      package: "entropy_src_pkg",
    }
    { struct:  "cs_aes_halt"
      type:    "req_rsp",
      name:    "cs_aes_halt"
      act:     "req"
      package: "entropy_src_pkg"
      desc:    '''
               Coordinate activity between CSRNG's AES and Entropy Source's SHA3.
               The idea is that Entropy Source requests CSRNG's AES to halt and waits for CSRNG to acknowledge before it starts its SHA3.
               While SHA3 runs, Entropy Source keeps the request high.
               CSRNG may not drop the acknowledge before Entropy Source drops the request.
               '''
    }
    { struct:  "logic"
      type:    "uni"
      name:    "entropy_src_rng_enable"
      act:     "req"
      width:   1
      package: ""
      desc:    '''
               Signal through which entropy_src enables the noise source.
               entropy_src will keep this signal high as long as it expects the noise source to operate.
               This is *not* a flow control signal through which entropy_src would exert backpressure on the noise source; rather this signal stays high while entropy_src is enabled.
               '''
    }
    { struct:  "logic"
      type:    "uni"
      name:    "entropy_src_rng_valid"
      act:     "rcv"
      width:   1
      package: ""
      desc:    '''
               Acknowledgement signal from the noise source.
               When '1', it indicates that the `entropy_src_rng_bit` data is valid and ready to be consumed.
               '''
    }
    { struct:  "logic"
      type:    "uni"
      name:    "entropy_src_rng_bits"
      act:     "rcv"
      width:   RngBusWidth
      package: ""
      desc:    '''
               Output data bus carrying the raw entropy bits from the noise source.
               These bits are valid when `entropy_src_rng_valid` is asserted.
               The width is determined by `RngBusWidth` parametrization.
               '''
    }
    { struct:  "logic"
      type:    "uni"
      name:    "entropy_src_xht_valid"
      act:     "req"
      width:   1
      package: ""
      desc:    '''
               Valid signal for the external health test interface.
               When asserted, it indicates that `entropy_src_xht_bits`, `entropy_src_xht_bit_sel`, and `entropy_src_xht_meta` are valid for consumption by the external health test.
               '''
    }
    { struct:  "logic"
      type:    "uni"
      name:    "entropy_src_xht_bits"
      act:     "req"
      width:   RngBusWidth
      package: ""
      desc:    '''
               Carries the raw entropy data from the entropy source to be consumed by the external health test module.
               The data on this bus is valid when `entropy_src_xht_valid` is asserted.
               The width is determined by `RngBusWidth` parametrization.
               '''
    }
    { struct:  "logic"
      type:    "uni"
      name:    "entropy_src_xht_bit_sel"
      act:     "req"
      width:   RngBusBitSelWidth
      package: ""
      desc:    '''
               Provides bit selection information for the raw entropy data.
               It specifies which specific bit or subset of bits from `entropy_src_xht_bit` should be used.
               The width is determined by `RngBusBitSelWidth` parametrization.
               '''
    }
    { struct:  "logic"
      type:    "uni"
      name:    "entropy_src_xht_health_test_window"
      act:     "req"
      width:   HealthTestWindowWidth
      package: ""
      desc:    '''
               Provides the window size of the health in bits.
               '''
    }
    { struct:  "entropy_src_xht_meta",
      type:    "req_rsp",
      name:    "entropy_src_xht_meta",
      act:     "req",
      package: "entropy_src_pkg",
    }
    { struct:  "mubi8"
      type:    "uni"
      name:    "otp_en_entropy_src_fw_read"
      act:     "rcv"
      package: "prim_mubi_pkg"
      default: "prim_mubi_pkg::MuBi8True"
    }
    { struct:  "mubi8"
      type:    "uni"
      name:    "otp_en_entropy_src_fw_over"
      act:     "rcv"
      package: "prim_mubi_pkg"
      default: "prim_mubi_pkg::MuBi8True"
    }
    { struct:  "logic"
      type:    "uni"
      name:    "rng_fips"
      act:     "req"
      width:   1
      package: ""
    }
  ],
  param_list: [
    # Regular parameters
    { name:    "RngBusWidth",
      type:    "int",
      default: "4",
      desc:    '''
               Defines the bit-width of the noise source data.
               Must be between 4 and 256 (inclusive) and divisible by 4.
               The divisibility by 4 is a prerequisite for the bucket health test.
               '''
      local:   "false",
      expose:  "true"
    },
    { name:    "RngBusBitSelWidth",
      type:    "int",
      default: "2",
      desc:    "Explicit parameter defining the width of the RNG bit selection vector (log2(RngBusWidth))"
      local:   "false",
      expose:  "true"
    },
    { name:    "HealthTestWindowWidth",
      type:    "int",
      default: "18",
      desc:    "Explicit parameter defining the width of the health test window (16 + log2(RngBusWidth))"
      local:   "false",
      expose:  "true"
    },
    { name:    "EsFifoDepth",
      type:    "int",
      default: "3",
      desc:    "Number of 384-bit entries in the esfinal FIFO"
      local:   "true",
      expose:  "true"
    },
    { name:    "EnCsAesHaltReqIf",
      type:    "bit",
      default: "1",
      desc:    "Enable (1) or disable (0) the CS AES halt request interface",
      local:   "true",
      expose:  "true"
    },
    { name:    "DistrFifoDepth",
      type:    "int unsigned",
      default: "3",
      desc:    "Number of 32-bit entries in the distr FIFO",
      local:   "true",
      expose:  "true"
    },
    { name:    "Stub",
      type:    "bit",
      default: "0",
      desc:    "Stub out the core of entropy_src logic"
      local:   "false",
      expose:  "true"
    },
    # Note: All parameters below are local, they are not actually configurable.
    # Selecting values different from the default values below might cause undefined behavior.
    { name:    "ObserveFifoDepth",
      type:    "int unsigned",
      default: "32",
      desc:    '''
                Number of 32-bit entries in the observe FIFO.
                Note that upon changing this parameter, the bit widths of the !!OBSERVE_FIFO_THRESH and !!OBSERVE_FIFO_DEPTH registers have to be manually adjusted.
                ''',
      local:   "true"
    },
  ]
  alert_list: [
    { name: "recov_alert",
      desc: "This alert is triggered upon the alert health test threshold criteria not met."
    }
    { name: "fatal_alert",
      desc: '''
            This alert triggers for any condition detected in the !!ERR_CODE register,
            which includes FIFO errors, COUNTER errors, FSM state errors,
            and also when integrity failures are detected on the TL-UL bus.
            ''',
    }
  ],
  features: [
    {
      name: "ENTROPY_SRC.MODE.BYPASS"
      desc: '''
            The boot-time / bypass mode is designed to provide an initial seed's worth of entropy with lower latency than the normal FIPS/CC compliant mode during chip boot up.
            This mode bypasses the hardware conditioning of ENTROPY_SRC and instead outputs raw entropy.
            However, health tests are still performed.

            Note that currently, only a window size of 384 bits for the health tests is supported and tested for boot-time / bypass mode.
            '''
    },
    {
      name: "ENTROPY_SRC.MODE.FIPS"
      desc: '''
            The FIPS/CC compliant mode is the primary mode of operation in which ENTROPY_SRC can generate entropy compliant with NIST SP 800-90B and AIS31 recommendations.
            In this mode, once the raw entropy has been health tested, it is passed into the hardware conditioner block which compresses the bits to ideally improve the min-entropy value compared to the digital noise source / physical true random number generator (PTRNG).
            The window size for the health tests and the conditioning is configurable by firmware with a default of 2048 bits.

            Note that ENTROPY_SRC uses the `es_fips` bit of the hardware interface to indicate whether the generated entropy is indeed FIPS/CC compliant.
            For this to be true the following prerequisites must be met in addition to running in FIPS/CC compliant mode:
            - !!CONF.RNG_BIT_ENABLE must be set to `kMultiBitBool4False` (see ENTROPY_SRC.RNG_BIT_ENABLE).
            - At most one of the !!ENTROPY_CONTROL.ES_ROUTE and !!ENTROPY_CONTROL.ES_TYPE fields needs to be set to `kMultiBitBool4True` but not both (see ENTROPY_SRC.ROUTE_TO_FIRMWARE).
            '''
    },
    {
      name: "ENTROPY_SRC.HEALTH_TESTS"
      desc: '''
            To screen the raw noise bits provided by the digital noise source / physical true random number generator (PTRNG) for statistical defects, ENTROPY_SRC implements multiple health tests which include:
            - Repetition Count and Adaptive Proportion tests as recommended by NIST SP 800-90B.
            - Bucket and Markov tests to look for correlations between the individual noise channels.

            Firmware can configure the threshold values separately for each health test.
            In case of health test failures, an interrupt is signaled.
            In addition, per-health-test failure counters are incremented.

            Firmware can configure threshold values for these per-health-test counters as well as for the total failure counter.
            In case any of these thresholds are hit, ENTROPY_SRC halts, signals a recoverable alert and sets the !!RECOV_ALERT_STS.ES_MAIN_SM_ALERT bit.
            Firmware then has to disable and re-enable ENTROPY_SRC to continue entropy generation and health testing.

            Firmware can configure the window size for the health tests.
            Note that currently, only a window size of 384 is supported and tested for boot-time / bypass mode.
            '''
    },
    {
      name: "ENTROPY_SRC.HEALTH_TESTS_EXT"
      desc: '''
            In addition to the internal health tests, ENTROPY_SRC features an interface for vendor-defined health tests implemented externally to ENTROPY_SRC.

            Note: Egret does not implement external vendor-defined health tests.
            '''
    },
    {
      name: "ENTROPY_SRC.RNG_BIT_ENABLE"
      desc: '''
            By default, ENTROPY_SRC uses all four channels of the digital noise source / physical true random number generator (PTRNG).
            Optionally, it is possible to use only one of the four channels which is useful for validation testing / using individual channels, e.g., in case of defects.

            Note that if only a single channel is used, ENTROPY_SRC will not generate FIPS qualified entropy (See also ENTROPY_SRC.MODE.FIPS).
            '''
    },
    {
      name: "ENTROPY_SRC.ROUTE_TO_FIRMWARE"
      desc: '''
            By default, ENTROPY_SRC routes the generated entropy out of ENTROPY_SRC via the hardware interface for consumption by CSRNG.
            For validation testing, it is possible to instead route the generated entropy to the !!ENTROPY_DATA register to be read by firmware.

            Note that for this to work the `otp_en_entropy_src_fw_read` input from OTP needs to be `kMultiBitBool8True`.

            Further note that when routing entropy to firmware, 1) no entropy is being passed to the hardware interface, and 2) it is possible to optionally bypass the hardware conditioner using !!ENTROPY_CONTROL.ES_TYPE.
            '''
    },
    {
      name: "ENTROPY_SRC.FW_OV.OBSERVE"
      desc: '''
            If this feature is enabled, firmware can monitor the post-health test entropy via !!FW_OV_RD_DATA register (observe FIFO).
            This can be useful, e.g., for validation testing.

            Note that the post-health test entropy bits collected in the observe FIFO continue to flow through the hardware pipeline and may eventually reach the hardware interface.

            Note that for this to work the `otp_en_entropy_src_fw_over` input from OTP needs to be set to `kMultiBitBool8True`.
            '''
    },
    {
      name: "ENTROPY_SRC.FW_OV.EXTRACT_AND_INSERT"
      desc: '''
            If this feature is enabled, firmware can extract entropy bits by reading from the !!FW_OV_RD_DATA register (observe FIFO) and insert entropy bits into the entropy flow by writing the !!FW_OV_WR_DATA register.
            This is can be useful for performing additional health tests and/or firmware-based conditioning.

            Note that it is possible to perform hardware conditioning of the inserted entropy bits.
            However, firmware has to manually trigger the conditioner via the !!FW_OV_SHA3_START register.

            Note that the post-health test entropy bits collected in the observe FIFO do not continue to flow through the hardware pipeline.
            Only entropy bits inserted by firmware through !!FW_OV_WR_DATA may eventually reach the block hardware interface.

            Note that for this feature to work the `otp_en_entropy_src_fw_over` input from OTP needs to be set to `kMultiBitBool8True`.
            '''
    },
  ],
  countermeasures: [
    { name: "CONFIG.REGWEN"
      desc: "Registers are protected from writes."
    }
    { name: "CONFIG.MUBI"
      desc: "Registers have multi-bit encoded fields."
    }
    { name: "CONFIG.REDUN"
      desc: "Threshold register has an inverted copy to compare against."
    }
    { name: "INTERSIG.MUBI"
      desc: "OTP signal used to enable software access to registers."
    }
    { name: "MAIN_SM.FSM.SPARSE"
      desc: "The ENTROPY_SRC main state machine uses a sparse state encoding."
    }
    { name: "ACK_SM.FSM.SPARSE"
      desc: "The ENTROPY_SRC ack state machine uses a sparse state encoding."
    }
    { name: "RNG.BKGN_CHK"
      desc: "Random number generator is protected with continuous background health checks."
    }
    { name: "FIFO.CTR.REDUN"
      desc: "The FIFO pointers of several FIFOs are implemented with duplicate counters."
    }
    { name: "CTR.REDUN"
      desc: "Counter hardening for all health test counters."
    }
    { name: "CTR.LOCAL_ESC"
      desc: "Redundant counter failures will cause a local escalation to the main state machine."
    }
    { name: "ESFINAL_RDATA.BUS.CONSISTENCY"
      desc: "Comparison on successive bus values for the post-conditioned entropy seed bus."
    }
    { name: "TILE_LINK.BUS.INTEGRITY"
      desc: "Tilelink end-to-end bus integrity scheme."
    }
    // See the KMAC/SHA3 module documentation for additional countermeasures provided by that design"
  ],

  regwidth: "32",
  registers: [
    { name: "ME_REGWEN",
      desc: "Register write enable for module enable register",
      swaccess: "rw0c",
      hwaccess: "none",
      fields: [
        {
            bits: "0",
            desc: ''' When true, the !!MODULE_ENABLE register can be modified.
            When false, it becomes read-only.
            '''
            resval: 1
        }
      ]
    },
    { name: "SW_REGUPD",
      desc: "Register write enable for control and threshold registers",
      swaccess: "rw0c",
      hwaccess: "hro",
      tags: [// Exclude from writes to these field because they cause side affects.
             "excl:CsrAllTests:CsrExclAll"]
      fields: [
        {
            bits: "0",
            desc: ''' When this bit true and the MODULE_ENABLE field is false,
            the REGWEN write enable bit read as true, and is distributed to
            all associated control and threshold registers.
            When false, these registers become read-only.
            '''
            resval: 1
        }
      ]
    },
    { name: "REGWEN",
      desc: "Register write enable for all control registers",
      swaccess: "ro",  // this particular enable bit is meant to be fully HW managed
      hwaccess: "hwo",
      tags: [// Internal HW can modify status register
             "excl:CsrNonInitTests:CsrExclCheck"]
      fields: [
        {
            bits: "0",
            desc: '''
                  This read-only write enable bit will allow write access to control and threshold registers that are associated with this bit, but only when the !!MODULE_ENABLE register is set to `kMultiBitBool4False` and the !!SW_REGUPD write enable bit is set to true.
                  When read as false, these registers become read-only.
            '''
            resval: 1
        }
      ]
    },
    { name: "MODULE_ENABLE",
      desc: "Module enable register",
      swaccess: "rw",
      hwaccess: "hro",
      regwen:   "ME_REGWEN",
      tags: [// Exclude from writes to these field because they cause side affects.
             "excl:CsrAllTests:CsrExclAll"]
      fields: [
        { bits: "3:0",
          mubi: true,
          name: "MODULE_ENABLE",
          desc: '''
                Setting this field to `kMultiBitBool4True` will enable the ENTROPY_SRC module. Setting this field to `kMultiBitBool4False` will effectively reset the module.
                The modules of the entropy complex may only be enabled and disabled in a specific order, see Programmers Guide for details.
                '''
          resval: false,
        },
      ]
    },
    { name: "CONF",
      desc: "Configuration register",
      swaccess: "rw",
      hwaccess: "hro",
      regwen:   "REGWEN",
      tags: [// Exclude from writes to these field because they cause side affects.
             "excl:CsrAllTests:CsrExclAll"]
      fields: [
        { bits: "3:0",
          name: "FIPS_ENABLE",
          mubi: true,
          desc: '''
                Setting this field to `kMultiBitBool4True` selects the mode targeting FIPS/CC compliance (in short FIPS mode) with hardware conditioning enabled.
                The ENTROPY_SRC block will use the FIPS_WINDOW and FIPS_THRESH values of the !!HEALTH_TEST_WINDOWS and health test thresholds register, respectively.
                Whether the ENTROPY_SRC block is indeed running with the configuration used for FIPS/CC validation is under the control of firmware.
                Thus, firmware must explicitly mark the produced entropy as FIPS qualified using the !!CONF.FIPS_FLAG field.
                Note that the hardware conditioning can still be disabled in FIPS mode by setting both !!ENTROPY_CONTROL.ES_ROUTE and !!ENTROPY_CONTROL.ES_TYPE fields to `kMultiBitBool4True`.
                However, no entropy is being passed to the block hardware interface in this mode.

                Setting this field to `kMultiBitBool4False` selects the boot-time / bypass mode in which the hardware conditioning is bypassed.
                '''
          resval: false,
        },
        { bits: "7:4",
          name: "FIPS_FLAG",
          mubi: true,
          desc: '''
                This flag indicates that the ENTROPY_SRC is setup with the configuration used for FIPS/CC validation.
                Setting this field to `kMultiBitBool4True` will set the FIPS flag for the ENTROPY_SRC block output to true.
                '''
          resval: false
        },
        { bits: "11:8",
          name: "RNG_FIPS",
          mubi: true,
          desc: '''
                Setting this field to `kMultiBitBool4True` sets the analog RNG into a conservative operation mode that may reduce the bit rate.
                In this mode, the RNG potentially outputs entropy with higher entropy per bit and with a simpler sampling mechanism.
                '''
          resval: false
        },
        { bits: "15:12",
          name: "RNG_BIT_ENABLE",
          mubi: true,
          desc: '''
                Setting this field to `kMultiBitBool4True` enables the single RNG bit mode, where only one bit is sampled per symbol.
                '''
          resval: false
        },
        { bits: "19:16",
          name: "THRESHOLD_SCOPE",
          mubi: true,
          desc: '''
                This field controls the scope (either by-line or by-sum) of the Adaptive Proportion and the Markov health tests.
                It has no effect if !!CONF.RNG_BIT_ENABLE is set to `kMultiBitBool4True`, i.e., if the ENTROPY_SRC is operating in single-channel mode.

                If set to `kMultiBitBool4False`, the minimum/maximum results of the individual, line-based tests are taken and compared against the configured thresholds.
                This allows detecting failures of individual noise source channels in multi-channel mode.
                If set to `kMultiBitBool4True`, the individual, line-based test results are summed up and then compared against the configured thresholds.
                This allows lowering the likelihood for coincidental test failures (higher alpha).

                Note that the value of THRESHOLD_SCOPE needs to be considered when defining the health test thresholds.
                '''
          resval: false
        },
        { bits: "23:20",
          name: "ENTROPY_DATA_REG_ENABLE",
          mubi: true,
          desc: '''
                Setting this field to `kMultiBitBool4True` will enable reading entropy values from the !!ENTROPY_DATA register.
                This function also requires that the otp_en_entropy_src_fw_read input is set to `kMultiBitBool8True`.
                '''
          resval: false
        }
        { bits: "31:24",
          name: "RNG_BIT_SEL",
          desc: '''
                When !!CONF.RNG_BIT_ENABLE is set, this field selects which bit from the RNG bus will be processed.
                If the IP is parameterized for a bus width less than 256 bits, the upper, unused bits of this register are ignored.
                '''
        },
      ]
    },
    { name: "ENTROPY_CONTROL",
      desc: "Entropy control register",
      swaccess: "rw",
      hwaccess: "hro",
      regwen:   "REGWEN",
      tags: [// Exclude from writes to these field because they cause side affects.
             "excl:CsrAllTests:CsrExclAll"]
      fields: [
        { bits: "3:0",
          name: "ES_ROUTE",
          mubi: true,
          desc: '''
                When this field is `kMultiBitBool4False`, the generated entropy will be forwarded out of this module to the hardware interface.
                Setting this field to `kMultiBitBool4True` routes the generated entropy to the !!ENTROPY_DATA register to be read by firmware.
                Note that for !!ENTROPY_DATA to become readable, also !!CONF.ENTROPY_DATA_REG_ENABLE needs to be set to `kMultiBitBool4True`.
                In addition, the otp_en_entropy_src_fw_read input needs to be set to `kMultiBitBool8True`.
                '''
          resval: false
        },
        { bits: "7:4",
          name: "ES_TYPE",
          mubi: true,
          desc: '''
                When this field is `kMultiBitBool4False`, the hardware conditioning inside the ENTROPY_SRC block is enabled.
                Setting this field to `kMultiBitBool4True` will bypass the hardware conditioning.
                For this to work, also !!ENTROPY_CONTROL.ES_ROUTE needs to be set to `kMultiBitBool4True` to route the unconditioned, raw entropy to the !!ENTROPY_DATA register.
                Alternatively, the hardware conditioning can be bypassed by setting !!CONF.FIPS_ENABLE to `kMultiBitBool4False`.
                This enables the bypass / boot-time mode.
                '''
          resval: false
        },
      ]
    },
    { name: "ENTROPY_DATA",
      desc: "Entropy data bits",
      swaccess: "ro",
      hwaccess: "hrw",
      hwext: "true",
      hwre: "true",
      fields: [
        { bits: "31:0",
          desc: '''
                A read of this register provides generated entropy bits to firmware.
                For this to work also !!CONF.ENTROPY_DATA_REG_ENABLE needs to be set to `kMultiBitBool4True`.
                In addition, the otp_en_entropy_src_fw_read input needs to be set to `kMultiBitBool8True`.
                '''
        }
      ]
    },
    { name: "HEALTH_TEST_WINDOWS",
      desc: "Health test windows register",
      swaccess: "rw",
      hwaccess: "hro",
      regwen:   "REGWEN",
      fields: [
        { bits: "15:0",
          name: "FIPS_WINDOW",
          desc: '''
                This is the window size in samples for all health tests.
                This value is used when entropy is being tested in FIPS/CC compliance mode (for simplicity referred to as FIPS mode).
                Note that the value defined in this register applies both to single-channel and multi-channel mode (see [`CONF.RNG_BIT_ENABLE`](#conf--rng_bit_enable)).

                Note that the number of tested bits taken by the conditioner to produce a seed is equal to the window size x symbol size, where the symbol size is 1 in single-channel mode.
                The only exception is the startup seed which is produced using the bits of two subsequent windows, i.e., 2 x window size x symbol tested bits.

                Note that NIST SP 800-90B (Table 2) requires the Adaptive Proportion Test to be run on 1024 or 512 samples in single-channel or multi-channel mode, respectively (see [`CONF.RNG_BIT_ENABLE`](#conf--rng_bit_enable)).
                The startup tests must be run on at least 1024 consecutive samples (see Section 4.3 Requirements for Health Tests of NIST SP 800-90B) and this block always uses two subsequent windows for startup health testing.
                The use of window sizes below 512 samples is thus not recommended as this may not comply with NIST SP 800-90B.
                '''
          resval: "512"
        }
        { bits: "31:16",
          name: "BYPASS_WINDOW",
          desc: '''
                This is the window size in bits for all health tests when running in bypass mode.
                This mode is active after reset for the first and only test run, or when this mode is programmed by firmware by setting !!CONF.FIPS_ENABLE to `kMultiBitBool4False`.
                The default value is 384 bits;

                Note that currently only a window size of 384 is supported and tested (this corresponds to the register default value 384).
                Do not use any other values, unless you know what you are doing.
                '''
          resval: "384"
        }
      ]
    },
    { name: "REPCNT_THRESHOLDS",
      desc: "Repetition Count Test thresholds register",
      swaccess: "rw",
      hwaccess: "hrw",
      hwext: "true",
      hwqe:  "true",
      regwen:   "REGWEN",
      tags: [// Exclude from writes to these field because they are one-way updates
             "excl:CsrNonInitTests:CsrExclWrite"]
      fields: [
        { bits: "15:0",
          name: "FIPS_THRESH",
          desc: '''This is the threshold for the Repetition Count Test.
                   This value is used in FIPS mode.
                   This register must be written before the module is enabled.
                   Writing to this register will only update the register if the
                   written value is less than the current value of this register.
                   A read from this register always reflects the current value.
                '''
          resval: "0xFFFF"
        }
        { bits: "31:16",
          name: "BYPASS_THRESH",
          desc: '''This is the threshold for the Repetition Count Test
                   running in bypass mode. This mode is active after reset for the
                   first and only test run, or when this mode is programmed by firmware.
                   This register must be written before the module is enabled.
                   Writing to this register will only update the register if the
                   written value is less than the current value of this register.
                   A read from this register always reflects the current value.
                '''
          resval: "0xFFFF"
        }
      ]
    },
    { name: "REPCNTS_THRESHOLDS",
      desc: "Repetition Count Symbol Test thresholds register",
      swaccess: "rw",
      hwaccess: "hrw",
      hwext: "true",
      hwqe:  "true",
      regwen:   "REGWEN",
      tags: [// Exclude from writes to these field because they are one-way updates
             "excl:CsrNonInitTests:CsrExclWrite"]
      fields: [
        { bits: "15:0",
          name: "FIPS_THRESH",
          desc: '''This is the threshold for the Repetition Count Symbol Test.
                   This value is used in FIPS mode.
                   This register must be written before the module is enabled.
                   Writing to this register will only update the register if the
                   written value is less than the current value of this register.
                   A read from this register always reflects the current value.
                '''
          resval: "0xFFFF"
        }
        { bits: "31:16",
          name: "BYPASS_THRESH",
          desc: '''This is the threshold for the Repetition Count Symbol Test
                   running in bypass mode. This mode is active after reset for the
                   first and only test run, or when this mode is programmed by firmware.
                   This register must be written before the module is enabled.
                   Writing to this register will only update the register if the
                   written value is less than the current value of this register.
                   A read from this register always reflects the current value.
                '''
          resval: "0xFFFF"
        }
      ]
    },
    { name: "ADAPTP_HI_THRESHOLDS",
      desc: "Adaptive proportion test high thresholds register",
      swaccess: "rw",
      hwaccess: "hrw",
      hwext: "true",
      hwqe:  "true",
      regwen:   "REGWEN",
      tags: [// Exclude from writes to these field because they are one-way updates
             "excl:CsrNonInitTests:CsrExclWrite"]
      fields: [
        { bits: "15:0",
          name: "FIPS_THRESH",
          desc: '''This is the threshold for the Adaptive Proportion Test.
                   This value is used in FIPS mode.
                   This register must be written before the module is enabled.
                   Writing to this register will only update the register if the
                   written value is less than the current value of this register.
                   A read from this register always reflects the current value.
                '''
          resval: "0xFFFF"
        }
        { bits: "31:16",
          name: "BYPASS_THRESH",
          desc: '''This is the threshold for the Adaptive Proportion Test
                   running in bypass mode. This mode is active after reset for the
                   first and only test run, or when this mode is programmed by firmware.
                   This register must be written before the module is enabled.
                   Writing to this register will only update the register if the
                   written value is less than the current value of this register.
                   A read from this register always reflects the current value.
                '''
          resval: "0xFFFF"
        }
      ]
    },
    { name: "ADAPTP_LO_THRESHOLDS",
      desc: "Adaptive proportion test low thresholds register",
      swaccess: "rw",
      hwaccess: "hrw",
      hwext: "true",
      hwqe:  "true",
      regwen:   "REGWEN",
      tags: [// Exclude from writes to these field because they are one-way updates
             "excl:CsrNonInitTests:CsrExclWrite"]
      fields: [
        { bits: "15:0",
          name: "FIPS_THRESH",
          desc: '''This is the threshold for the Adaptive Proportion Test.
                   This value is used in FIPS mode.
                   This register must be written before the module is enabled.
                   Writing to this register will only update the register if the
                   written value is greater than the current value of this register.
                   A read from this register always reflects the current value.
                '''
          resval: "0x0000"
        }
        { bits: "31:16",
          name: "BYPASS_THRESH",
          desc: '''This is the threshold for the Adaptive Proportion Test
                   running in bypass mode. This mode is active after reset for the
                   first and only test run, or when this mode is programmed by firmware.
                   This register must be written before the module is enabled.
                   Writing to this register will only update the register if the
                   written value is greater than the current value of this register.
                   A read from this register always reflects the current value.
                '''
          resval: "0x0000"
        }
      ]
    },
    { name: "BUCKET_THRESHOLDS",
      desc: "Bucket test thresholds register",
      swaccess: "rw",
      hwaccess: "hrw",
      hwext: "true",
      hwqe:  "true",
      regwen:   "REGWEN",
      tags: [// Exclude from writes to these field because they are one-way updates
             "excl:CsrNonInitTests:CsrExclWrite"]
      fields: [
        { bits: "15:0",
          name: "FIPS_THRESH",
          desc: '''This is the threshold size for the bucket health test.
                   This value is used in FIPS mode.
                   This register must be written before the module is enabled.
                   Writing to this register will only update the register if the
                   written value is less than the current value of this register.
                   A read from this register always reflects the current value.
                '''
          resval: "0xFFFF"
        }
        { bits: "31:16",
          name: "BYPASS_THRESH",
          desc: '''This is the threshold size for the bucket health test
                   running in bypass mode. This mode is active after reset for the
                   first and only test run, or when this mode is programmed by firmware.
                   This register must be written before the module is enabled.
                   Writing to this register will only update the register if the
                   written value is less than the current value of this register.
                   A read from this register always reflects the current value.
                '''
          resval: "0xFFFF"
        }
      ]
    },
    { name: "MARKOV_HI_THRESHOLDS",
      desc: "Markov test high thresholds register",
      swaccess: "rw",
      hwaccess: "hrw",
      hwext: "true",
      hwqe:  "true",
      regwen:   "REGWEN",
      tags: [// Exclude from writes to these field because they are one-way updates
             "excl:CsrNonInitTests:CsrExclWrite"]
      fields: [
        { bits: "15:0",
          name: "FIPS_THRESH",
          desc: '''This is the threshold size for the Markov health test.
                   This value is used in FIPS mode.
                   This register must be written before the module is enabled.
                   Writing to this register will only update the register if the
                   written value is less than the current value of this register.
                   A read from this register always reflects the current value.
                '''
          resval: "0xFFFF"
        }
        { bits: "31:16",
          name: "BYPASS_THRESH",
          desc: '''This is the threshold size for the Markov health test
                   running in bypass mode. This mode is active after reset for the
                   first and only test run, or when this mode is programmed by firmware.
                   This register must be written before the module is enabled.
                   Writing to this register will only update the register if the
                   written value is less than the current value of this register.
                   A read from this register always reflects the current value.
                '''
          resval: "0xFFFF"
       }
      ]
    },
    { name: "MARKOV_LO_THRESHOLDS",
      desc: "Markov test low thresholds register",
      swaccess: "rw",
      hwaccess: "hrw",
      hwext: "true",
      hwqe:  "true",
      regwen:   "REGWEN",
      tags: [// Exclude from writes to these field because they are one-way updates
             "excl:CsrNonInitTests:CsrExclWrite"]
      fields: [
        { bits: "15:0",
          name: "FIPS_THRESH",
          desc: '''This is the threshold size for the Markov health test.
                   This value is used in FIPS mode.
                   This register must be written before the module is enabled.
                   Writing to this register will only update the register if the
                   written value is greater than the current value of this register.
                   A read from this register always reflects the current value.
                '''
          resval: "0x0000"
        }
        { bits: "31:16",
          name: "BYPASS_THRESH",
          desc: '''This is the threshold size for the Markov health test
                   running in bypass mode. This mode is active after reset for the
                   first and only test run, or when this mode is programmed by firmware.
                   This register must be written before the module is enabled.
                   Writing to this register will only update the register if the
                   written value is greater than the current value of this register.
                   A read from this register always reflects the current value.
                '''
          resval: "0x0000"
        }
      ]
    },
    { name: "EXTHT_HI_THRESHOLDS",
      desc: "External health test high thresholds register",
      swaccess: "rw",
      hwaccess: "hrw",
      hwext: "true",
      hwqe:  "true",
      regwen:   "REGWEN",
      tags: [// Exclude from writes to these field because they are one-way updates
             "excl:CsrNonInitTests:CsrExclWrite"]
      fields: [
        { bits: "15:0",
          name: "FIPS_THRESH",
          desc: '''This is the threshold size for the external health test.
                   This value is used in FIPS mode.
                   This register must be written before the module is enabled.
                   Writing to this register will only update the register if the
                   written value is less than the current value of this register.
                   A read from this register always reflects the current value.
                '''
          resval: "0xFFFF"
        }
        { bits: "31:16",
          name: "BYPASS_THRESH",
          desc: '''This is the threshold size for the external health test
                   running in bypass mode. This mode is active after reset for the
                   first and only test run, or when this mode is programmed by firmware.
                   This register must be written before the module is enabled.
                   Writing to this register will only update the register if the
                   written value is less than the current value of this register.
                   A read from this register always reflects the current value.
                '''
          resval: "0xFFFF"
        }
      ]
    },
    { name: "EXTHT_LO_THRESHOLDS",
      desc: "External health test low thresholds register",
      swaccess: "rw",
      hwaccess: "hrw",
      hwext: "true",
      hwqe:  "true",
      regwen:   "REGWEN",
      tags: [// Exclude from writes to these field because they are one-way updates
             "excl:CsrNonInitTests:CsrExclWrite"]
      fields: [
        { bits: "15:0",
          name: "FIPS_THRESH",
          desc: '''This is the threshold size for the external health test.
                   This value is used in FIPS mode.
                   This register must be written before the module is enabled.
                   Writing to this register will only update the register if the
                   written value is greater than the current value of this register.
                   A read from this register always reflects the current value.
                '''
          resval: "0x0000"
        }
        { bits: "31:16",
          name: "BYPASS_THRESH",
          desc: '''This is the threshold size for the external health test
                   running in bypass mode. This mode is active after reset for the
                   first and only test run, or when this mode is programmed by firmware.
                   This register must be written before the module is enabled.
                   Writing to this register will only update the register if the
                   written value is greater than the current value of this register.
                   A read from this register always reflects the current value.
                '''
          resval: "0x0000"
        }
      ]
    },
    { name:     "HT_WATERMARK_NUM",
      desc:     "Health test watermark number register",
      swaccess: "rw",
      hwaccess: "hrw",
      hwext:    "true",
      hwqe:     "true",
      regwen:   "REGWEN",
      tags: [ // Internal HW can modify status register
             "excl:CsrAllTests:CsrExclCheck"]
      fields: [
        { bits: "3:0",
          name: "HT_WATERMARK_NUM",
          resval: "0",
          desc: '''
                The value of this field defines the health test for which the HT_WATERMARK register records the watermark.
                Invalid input values, i.e., values greater than 8 are mapped to 0.

                This register must be written before the module is enabled.
                '''
          enum: [
            { value: "0",
              name: "REPCNT_HI",
              desc: '''
                    Repetition Count Test high watermark.
                    '''
            },
            { value: "1",
              name: "REPCNTS_HI",
              desc: '''
                    Repetition Count Symbol Test high watermark.
                    '''
            },
            { value: "2",
              name: "ADAPTP_HI",
              desc: '''
                    Adaptive proportion test high watermark.
                    '''
            },
            { value: "3",
              name: "ADAPTP_LO",
              desc: '''
                    Adaptive proportion test low watermark.
                    '''
            },
            { value: "4",
              name: "BUCKET_HI",
              desc: '''
                    Bucket test high watermark.
                    '''
            },
            { value: "5",
              name: "MARKOV_HI",
              desc: '''
                    Markov test high watermark.
                    '''
            },
            { value: "6",
              name: "MARKOV_LO",
              desc: '''
                    Markov test low watermark.
              '''
            },
            { value: "7",
              name: "EXTHT_HI",
              desc: '''
                    External health test high watermark.
                    '''
            },
            { value: "8",
              name: "EXTHT_LO",
              desc: '''
                    External health test low watermark.
                    '''
            }
          ]
        }
      ]
    },
    { name:     "HT_WATERMARK",
      desc:     "Health test watermark register",
      swaccess: "ro",
      hwaccess: "hwo",
      hwext:    "true",
      tags: [ // Internal HW drives this register.
             "excl:CsrAllTests:CsrExclCheck"]
      fields: [
        { bits: "15:0",
          name: "HT_WATERMARK",
          resval: "0",
          desc: '''
                Watermark value for health test selected by HT_WATERMARK_NUM.
                After a reset, this register always reads as 0.
                If a low watermark is configured in HT_WATERMARK_NUM, this register is cleared to all-1s after enabling ENTROPY_SRC.
                '''
        }
      ]
    },
    { name:     "REPCNT_TOTAL_FAILS",
      desc:     "Repetition Count Test failure counter register",
      swaccess: "ro",
      hwaccess: "hwo",
      hwext: "true",
      fields: [
        { bits: "31:0",
          name: "REPCNT_TOTAL_FAILS",
          desc: '''This register will hold a running count of test failures observed
                   during normal operation. It will persist until cleared.
                '''
        }
      ]
    },
    { name:     "REPCNTS_TOTAL_FAILS",
      desc:     "Repetition Count Symbol Test failure counter register",
      swaccess: "ro",
      hwaccess: "hwo",
      hwext: "true",
      fields: [
        { bits: "31:0",
          name: "REPCNTS_TOTAL_FAILS",
          desc: '''This register will hold a running count of test failures observed
                   during normal operation. It will persist until cleared.
                '''
        }
      ]
    },
    { name:     "ADAPTP_HI_TOTAL_FAILS",
      desc:     "Adaptive proportion high test failure counter register",
      swaccess: "ro",
      hwaccess: "hwo",
      hwext: "true",
      fields: [
        { bits: "31:0",
          name: "ADAPTP_HI_TOTAL_FAILS",
          desc: '''This register will hold a running count of test failures observed
                   during normal operation. It will persist until cleared.
                '''
        }
      ]
    },
    { name:     "ADAPTP_LO_TOTAL_FAILS",
      desc:     "Adaptive proportion low test failure counter register",
      swaccess: "ro",
      hwaccess: "hwo",
      hwext: "true",
      fields: [
        { bits: "31:0",
          name: "ADAPTP_LO_TOTAL_FAILS",
          desc: '''This register will hold a running count of test failures observed
                   during normal operation. It will persist until cleared.
                '''
        }
      ]
    },
    { name:     "BUCKET_TOTAL_FAILS",
      desc:     "Bucket test failure counter register",
      swaccess: "ro",
      hwaccess: "hwo",
      hwext: "true",
      fields: [
        { bits: "31:0",
          name: "BUCKET_TOTAL_FAILS",
          desc: '''This register will hold a running count of test failures observed
                   during normal operation. It will persist until cleared.
                '''
        }
      ]
    },
    { name:     "MARKOV_HI_TOTAL_FAILS",
      desc:     "Markov high test failure counter register",
      swaccess: "ro",
      hwaccess: "hwo",
      hwext: "true",
      fields: [
        { bits: "31:0",
          name: "MARKOV_HI_TOTAL_FAILS",
          desc: '''This register will hold a running count of test failures observed
                   during normal operation. It will persist until cleared.
                '''
        }
      ]
    },
    { name:     "MARKOV_LO_TOTAL_FAILS",
      desc:     "Markov low test failure counter register",
      swaccess: "ro",
      hwaccess: "hwo",
      hwext: "true",
      fields: [
        { bits: "31:0",
          name: "MARKOV_LO_TOTAL_FAILS",
          desc: '''This register will hold a running count of test failures observed
                   during normal operation. It will persist until cleared.
                '''
        }
      ]
    },
    { name:     "EXTHT_HI_TOTAL_FAILS",
      desc:     "External health test high threshold failure counter register",
      swaccess: "ro",
      hwaccess: "hwo",
      hwext: "true",
      fields: [
        { bits: "31:0",
          name: "EXTHT_HI_TOTAL_FAILS",
          desc: '''This register will hold a running count of test failures observed
                   during normal operation. It will persist until cleared.
                '''
        }
      ]
    },
    { name:     "EXTHT_LO_TOTAL_FAILS",
      desc:     "External health test low threshold failure counter register",
      swaccess: "ro",
      hwaccess: "hwo",
      hwext: "true",
      fields: [
        { bits: "31:0",
          name: "EXTHT_LO_TOTAL_FAILS",
          desc: '''This register will hold a running count of test failures observed
                   during normal operation. It will persist until cleared.
                '''
        }
      ]
    },
    { name: "ALERT_THRESHOLD",
      desc: '''
            Alert threshold register

            This register determines during how many subsequent health test windows one or more health test failures can occur before a recoverable alert is raised and the ENTROPY_SRC block stops operating.
            Note that continuous health tests such as the Repetition Count Test or the Repetition Count Symbol Test can trigger multiple test failures within a single window.
            Each symbol for which at least one continuous health test fails counts separately towards the threshold.
            In case the configured threshold is reached, firmware needs to disable/re-enable the block to restart operation including the startup health testing.

            Note that when reaching the threshold while running in Firmware Override: Extract & Insert mode, the recoverable alert is not raised nor does the block stop operating.
            In other modes, the generation of the recoverable alert can be disabled by configuring a value of zero.
            The default value is set to two.
            '''
      swaccess: "rw",
      hwaccess: "hro",
      regwen:   "REGWEN",
      tags: [// Setting this register needs to not be random.
                 "excl:CsrNonInitTests:CsrExclWrite"]
      fields: [
        { bits: "15:0",
          name: "ALERT_THRESHOLD",
          desc: '''
                This is the threshold at which a recoverable alert is signaled and the blocks stops operating.
                '''
          resval: "0x0002"
        }
        { bits: "31:16",
          name: "ALERT_THRESHOLD_INV",
          desc: '''
                This should be set to the value above, but inverted.
                '''
          resval: "0xfffd"
        }
      ]
    },
    { name: "ALERT_SUMMARY_FAIL_COUNTS",
      desc: '''
            Alert summary failure counts register

            This register holds the total number of subsequent health test windows during which one or more health test failures occurred.
            For information on which health tests failed specifically, refer to !!ALERT_FAIL_COUNTS and !!EXTHT_FAIL_COUNTS.
            Note that continuous health tests such as the Repetition Count Test or the Repetition Count Symbol Test can trigger multiple test failures within a single window.
            Each symbol for which at least one continuous health test fails is counted separately.

            If the value of this register reaches the value configured in the !!ALERT_THRESHOLD register, a recoverable alert is raised and the ENTROPY_SRC block stops operating.
            If an alert is signaled, the value persists until it is cleared by firmware.

            The register is automatically cleared after every passing health test window unless the ENTROPY_SRC is configured in Firmware Override: Extract & Insert mode.
            The register is also cleared after re-enabling the block.
            '''
      swaccess: "ro",
      hwaccess: "hwo",
      hwext: "true",
      fields: [
        { bits: "15:0",
          name: "ANY_FAIL_COUNT",
          desc: '''
                The number of subsequent health test windows during which one or more health tests failed.
                '''
        }
      ]
    },
    { name: "ALERT_FAIL_COUNTS",
      desc: '''
            Alert failure counts register

            This register holds the number of health test failures since the last passing health test window.
            The values are reported on a per-test basis.
            Note that if multiple health tests fail for a certain symbol or window, the value in !!ALERT_SUMMARY_FAIL_COUNTS is incremented by just one whereas multiple fields in this register may get incremented.

            All fields of this register are automatically cleared after every passing health test window unless the ENTROPY_SRC is configured in Firmware Override: Extract & Insert mode.
            The fields are also cleared after re-enabling the block.
            '''
      swaccess: "ro",
      hwaccess: "hwo",
      hwext: "true",
      fields: [
        { bits: "7:4",
          name: "REPCNT_FAIL_COUNT",
          desc: '''
                The number of symbols during which this test failed since the last passing health test window.
                '''
        }
        { bits: "11:8",
          name: "ADAPTP_HI_FAIL_COUNT",
          desc: '''
                The number of health test windows during which this test failed since the last passing health test window.
                '''
        }
        { bits: "15:12",
          name: "ADAPTP_LO_FAIL_COUNT",
          desc: '''
                The number of health test windows during which this test failed since the last passing health test window.
                '''
        }
        { bits: "19:16",
          name: "BUCKET_FAIL_COUNT",
          desc: '''
                The number of health test windows during which this test failed since the last passing health test window.
                '''
        }
        { bits: "23:20",
          name: "MARKOV_HI_FAIL_COUNT",
          desc: '''
                The number of health test windows during which this test failed since the last passing health test window.
                '''
        }
        { bits: "27:24",
          name: "MARKOV_LO_FAIL_COUNT",
          desc: '''
                The number of health test windows during which this test failed since the last passing health test window.
                '''
        }
        { bits: "31:28",
          name: "REPCNTS_FAIL_COUNT",
          desc: '''
                The number of symbols during which this test failed since the last passing health test window.
                '''
        }
      ]
    },
    { name: "EXTHT_FAIL_COUNTS",
      desc: '''
            External health test alert failure counts register

            This register holds the number of external health test failures since the last passing health test window.
            The values are reported on a per-test basis.
            Note that if multiple health tests fail for a certain symbol or window, the value in !!ALERT_SUMMARY_FAIL_COUNTS is incremented by just one whereas multiple fields in this register may get incremented.

            All fields of this register are automatically cleared after every passing health test window unless the ENTROPY_SRC is configured in Firmware Override: Extract & Insert mode.
            The fields are also cleared after re-enabling the block.
            '''
      swaccess: "ro",
      hwaccess: "hwo",
      hwext: "true",
      fields: [
        { bits: "3:0",
          name: "EXTHT_HI_FAIL_COUNT",
          desc: '''
                The number of symbols for continuous tests or health test windows for window-based tests during which this test failed since the last passing health test window.
                '''
        }
        { bits: "7:4",
          name: "EXTHT_LO_FAIL_COUNT",
          desc: '''
                The number of symbols for continuous tests or health test windows for window-based tests during which this test failed since the last passing health test window.
                '''
        }
      ]
    },
    { name: "FW_OV_CONTROL",
      desc: "Firmware override control register",
      swaccess: "rw",
      hwaccess: "hro",
      regwen:   "REGWEN",
      tags: [// Exclude from writes to these field because they cause side affects.
             "excl:CsrAllTests:CsrExclAll"]
      fields: [
        { bits: "3:0",
          name: "FW_OV_MODE",
          desc: '''
                Setting this field to `kMultiBitBool4True` will put the entropy flow in firmware override mode.
                In this mode, firmware can monitor the post-health test entropy by reading
                the observe FIFO (see !!FW_OV_RD_DATA).
                This includes the entropy bits used for the startup health testing.
                For this to work, the otp_en_entropy_src_fw_over input needs to be set to `kMultiBitBool8True`.

                Note that the post-health test entropy bits collected in the observe FIFO continue to flow through the hardware pipeline and may eventually reach the block hardware interface.
                '''
          mubi: true,
          resval: false
        },
        { bits: "7:4",
          name: "FW_OV_ENTROPY_INSERT",
          desc: '''
                Setting this field to `kMultiBitBool4True` allows firmware to extract entropy bits by reading the observe FIFO (see !!FW_OV_RD_DATA) and insert entropy bits into the entropy flow by writing the !!FW_OV_WR_DATA register.
                This is useful e.g. for performing additional health tests and/or firmware-based conditioning.
                For this to work, !!FW_OV_CONTROL.FW_OV_MODE needs to be set to `kMultiBitBool4True`.
                In addition, the otp_en_entropy_src_fw_over input needs to be set to `kMultiBitBool8True`.

                Firmware can use the hardware conditioning for the inserted entropy bits (see !!FW_OV_SHA3_START).

                Note that if the field is set to `kMultiBitBool4True`, post-health test entropy bits do NOT continue to flow through the hardware pipeline.
                Also, the !!FW_OV_CONTROL.FW_OV_MODE bit must be set.
                The observe FIFO will collect 2 kBit of contiguous entropy bits.
                Any entropy bits arriving after the observe FIFO is full are being discarded.
                Firmware has to read out the entire observe FIFO to restart entropy collection.
                Only entropy bits inserted by firmware by writing !!FW_OV_WR_DATA may eventually reach the block hardware interface.

                Also, the hardware startup health testing is skipped and firmware becomes responsible for performing any startup health testing.
                '''
          mubi: true,
          resval: false
        },
      ]
    },
    { name: "FW_OV_SHA3_START",
      desc: "Firmware override sha3 block start control register",
      swaccess: "rw",
      hwaccess: "hro",
      tags: [// Exclude from writes to these field because they cause side affects.
             "excl:CsrAllTests:CsrExclAll"]
      fields: [
        { bits: "3:0",
          name: "FW_OV_INSERT_START",
          desc: '''
                Setting this field to `kMultiBitBool4True` will instruct the ENTROPY_SRC main state machine to start the SHA3 process and be ready to accept entropy data.
                This field should be set prior to writing the !!FW_OV_WR_DATA register.
                Once all data has been written, this field should be set to `kMultiBitBool4False`.
                Once that happened, the SHA3 block will finish processing and push the result into the esfinal FIFO.

                Note that clearing this bit to `kMultiBitBool4False` while there is still unprocessed entropy in !!FW_OV_WR_DATA will start the SHA3 engine before data can be added to the input message, and will also signal a recoverable alert in !!RECOV_ALERT_STS.ES_FW_OV_DISABLE_ALERT.
                To avoid this, check that !!FW_OV_WR_FIFO_FULL is clear before setting this field to `kMultiBitBool4False`.
                '''
          mubi: true,
          resval: false
        },
      ]
    },
    { name:     "FW_OV_WR_FIFO_FULL",
      desc:     "Firmware override FIFO write full status register",
      swaccess: "ro",
      hwaccess: "hwo",
      hwext: "true",
      fields: [
        { bits: "0",
          name: "FW_OV_WR_FIFO_FULL",
          desc: '''When this bit is clear, writes to the FW_OV_WR_DATA register are allowed.
                If this bit is set, it is the equivalent to a FIFO full condition, and writes
                to the FW_OV_WR_DATA register must be delayed until this bit is reset.
                '''
        }
      ]
    },
    { name:     "FW_OV_RD_FIFO_OVERFLOW",
      desc:     "Firmware override observe FIFO overflow status",
      swaccess: "ro",
      hwaccess: "hwo",
      hwext: "false",
      fields: [
        { bits: "0",
          name: "FW_OV_RD_FIFO_OVERFLOW",
          desc: '''
                This bit is set by hardware whenever RNG data is lost due to an overflow condition
                in the observe FIFO. The RNG data rate is slow enough that firmware should always
                be able to keep up. This register meanwhile provides an additional check to confirm
                that bytes read from the !!FW_OV_RD_DATA register represent contiguous RNG samples.
                If an overflow event occurs, this bit is cleared by hardware as soon as the FIFO is emptied.
                '''
        }
      ]
    },
    { name: "FW_OV_RD_DATA",
      desc: "Firmware override observe FIFO read register",
      swaccess: "ro",
      hwaccess: "hrw",
      hwext: "true",
      hwre: "true",
      fields: [
        { bits: "31:0",
          desc: '''
                A read of this register pops and returns the top of the observe FIFO.
                For this to work, the !!FW_OV_CONTROL.FW_OV_MODE field needs to be set to `kMultiBitBool4True`
                In addition, the otp_en_entropy_src_fw_over input needs to be set to `kMultiBitBool8True`.
                Reading this register while the observe FIFO is empty results in a fatal error with !!ERR_CODE.FIFO_READ_ERR and !!ERR_CODE.SFIFO_OBSERVE_ERR going high.
                '''
        }
      ]
    },
    { name: "FW_OV_WR_DATA",
      desc: "Firmware override FIFO write register",
      swaccess: "wo",
      hwaccess: "hro",
      hwext: "true",
      hwqe: "true",
      fields: [
        { bits: "31:0",
          desc: '''
                A write to this register will insert entropy back into the entropy source module flow.
                For this to work, both the !!FW_OV_CONTROL.FW_OV_MODE and !!FW_OV_CONTROL.FW_OV_ENTROPY_INSERT fields need to be set to `kMultiBitBool4True`.
                In addition, the otp_en_entropy_src_fw_over input needs to be set to `kMultiBitBool8True`.
                '''
        }
      ]
    },
    { name: "OBSERVE_FIFO_THRESH",
      desc: "Observe FIFO threshold register",
      swaccess: "rw",
      hwaccess: "hro",
      regwen:   "REGWEN",
      fields: [
        { bits: "5:0",
          desc: '''This field will set the threshold that the depth of the observe FIFO
                will be compared with when setting the interrupt status bit.
                Note: a value of zero is reserved and not to be used.
                '''
          resval: "0x10"
        }
      ]
    },
    { name: "OBSERVE_FIFO_DEPTH",
      desc: "Observe FIFO depth register",
      swaccess: "ro",
      hwaccess: "hwo",
      hwext: "true",
      fields: [
        { bits: "5:0",
          desc: '''This field will hold the current depth of the observe FIFO.
                '''
        }
      ]
    },
    { name:     "DEBUG_STATUS",
      desc:     "Debug status register",
      swaccess: "ro",
      hwaccess: "hwo",
      hwext: "true",
      fields: [
        { bits: "1:0",
          name: "ENTROPY_FIFO_DEPTH",
          desc: "This is the depth of the entropy source FIFO."
        }
        { bits: "5:3",
          name: "SHA3_FSM",
          desc: "This is the SHA3 finite state machine current state."
        }
        { bits: "6",
          name: "SHA3_BLOCK_PR",
          desc: "This is the SHA3 block processed signal current state."
        }
        { bits: "7",
          name: "SHA3_SQUEEZING",
          desc: "This is the SHA3 squeezing signal current state."
        }
        { bits: "8",
          name: "SHA3_ABSORBED",
          desc: "This is the SHA3 absorbed signal current state."
        }
        { bits: "9",
          name: "SHA3_ERR",
          desc: "This is a logic-or of all of the SHA3 error signals."
        }
        { bits: "16",
          name: "MAIN_SM_IDLE",
          desc: "The entropy_src main state machine is in the idle state."
          resval: 1
        }
        { bits: "17",
          name: "MAIN_SM_BOOT_DONE",
          desc: "The entropy_src main state machine is in the boot phase done state."
        }
      ]
    },
    {
      name: "RECOV_ALERT_STS",
      desc: "Recoverable alert status register",
      swaccess: "rw0c",
      hwaccess: "hwo",
      fields: [
        { bits: "0",
          name: "FIPS_ENABLE_FIELD_ALERT",
          desc: '''
                This bit is set when the FIPS_ENABLE field in the !!CONF register is set to a value other than `kMultiBitBool4False` or `kMultiBitBool4True`.
                Writing a zero resets this status bit.
                '''
        }
        { bits: "1",
          name: "ENTROPY_DATA_REG_EN_FIELD_ALERT",
          desc: '''
                This bit is set when the ENTROPY_DATA_REG_ENABLE field in the !!CONF register is set to a value other than `kMultiBitBool4False` or `kMultiBitBool4True`.
                Writing a zero resets this status bit.
                '''
        }
        { bits: "2",
          name: "MODULE_ENABLE_FIELD_ALERT",
          desc: '''
                This bit is set when the MODULE_ENABLE field in the !!MODULE_ENABLE register is set to a value other than `kMultiBitBool4False` or `kMultiBitBool4True`.
                Writing a zero resets this status bit.
                '''
        }
        { bits: "3",
          name: "THRESHOLD_SCOPE_FIELD_ALERT",
          desc: '''
                This bit is set when the THRESHOLD_SCOPE field in the !!CONF register is set to a value other than `kMultiBitBool4False` or `kMultiBitBool4True`.
                Writing a zero resets this status bit.
                '''
        }
        { bits: "5",
          name: "RNG_BIT_ENABLE_FIELD_ALERT",
          desc: '''
                This bit is set when the RNG_BIT_ENABLE field in the !!CONF register is set to a value other than `kMultiBitBool4False` or `kMultiBitBool4True`.
                Writing a zero resets this status bit.
                '''
        }
        { bits: "7",
          name: "FW_OV_SHA3_START_FIELD_ALERT",
          desc: '''
                This bit is set when the FW_OV_SHA3_START field in the !!FW_OV_SHA3_START register is set to a value other than `kMultiBitBool4False` or `kMultiBitBool4True`.
                Writing a zero resets this status bit.
                '''
        }
        { bits: "8",
          name: "FW_OV_MODE_FIELD_ALERT",
          desc: '''
                This bit is set when the FW_OV_MODE field in the !!FW_OV_CONTROL register is set to a value other than `kMultiBitBool4False` or `kMultiBitBool4True`.
                Writing a zero resets this status bit.
                '''
        }
        { bits: "9",
          name: "FW_OV_ENTROPY_INSERT_FIELD_ALERT",
          desc: '''
                This bit is set when the FW_OV_ENTROPY_INSERT field in the !!FW_OV_CONTROL register is set to a value other than `kMultiBitBool4False` or `kMultiBitBool4True`.
                Writing a zero resets this status bit.
                '''
        }
        { bits: "10",
          name: "ES_ROUTE_FIELD_ALERT",
          desc: '''
                This bit is set when the ES_ROUTE field in the !!ENTROPY_CONTROL register is set to a value other than `kMultiBitBool4False` or `kMultiBitBool4True`.
                Writing a zero resets this status bit.
                '''
        }
        { bits: "11",
          name: "ES_TYPE_FIELD_ALERT",
          desc: '''
                This bit is set when the ES_TYPE field in the !!ENTROPY_CONTROL register is set to a value other than `kMultiBitBool4False` or `kMultiBitBool4True`.
                Writing a zero resets this status bit.
                '''
        }
        { bits: "12",
          name: "ES_MAIN_SM_ALERT",
          desc: '''
                This bit is set when the main state machine detects a threshold failure state.
                Writing a zero resets this status bit.
                '''
        }
        { bits: "13",
          name: "ES_BUS_CMP_ALERT",
          desc: '''
                This bit is set when the internal entropy bus value is equal to the prior
                valid value on the bus, indicating a possible attack.
                Writing a zero resets this status bit.
                '''
        }
        { bits: "14",
          name: "ES_THRESH_CFG_ALERT",
          desc: '''
                This bit is set when the !!ALERT_THRESHOLD register is not configured properly.
                The upper field must be the exact inverse of the lower field.
                Writing a zero resets this status bit.
                '''
        }
        { bits: "15",
          name: "ES_FW_OV_WR_ALERT",
          desc: '''
                This bit is set when the packer FIFO has been written but was full at the time,
                and in both FW_OV_MODE and FW_OV_ENTROPY_INSERT modes.
                This alert would normally be the result of not monitoring the !!FW_OV_WR_FIFO_FULL
                register before each write to the !!FW_OV_WR_DATA register.
                Writing a zero resets this status bit.
                '''
        }
        { bits: "16",
          name: "ES_FW_OV_DISABLE_ALERT",
          desc: '''
                This bit is set when !!FW_OV_SHA3_START has been set to `kMultiBitBool4False`, without waiting for the bypass packer FIFO to clear.
                The final entropy entry in the FIFO will not be included in the SHA3 digest.
                (Rather it will be added to the subsequent SHA3 digest.)
                To avoid this alert, monitor !!FW_OV_WR_FIFO_FULL before clearing !!FW_OV_SHA3_START.
                This alert only applies when both !!FW_OV_CONTROL.FW_OV_MODE and !!FW_OV_CONTROL.FW_OV_ENTROPY_INSERT are set to `kMultiBitBool4True`.
                Writing a zero resets this status bit.
                '''
        }
        { bits: "17",
          name: "FIPS_FLAG_FIELD_ALERT",
          desc: '''
                This bit is set when the FIPS_FLAG field in the !!CONF register is set to a value other than `kMultiBitBool4False` or `kMultiBitBool4True`.
                Writing a zero resets this status bit.
                '''
        }
        { bits: "18",
          name: "RNG_FIPS_FIELD_ALERT",
          desc: '''
                This bit is set when the RNG_FIPS field in the !!CONF register is set to a value other than `kMultiBitBool4False` or `kMultiBitBool4True`.
                Writing a zero resets this status bit.
                '''
        }
        { bits: "31",
          name: "POSTHT_ENTROPY_DROP_ALERT",
          desc: '''
                This bit is set when post-health test entropy bits are being dropped from the hardware pipeline.
                The pipeline can drop individual symbols at the input of the postht FIFO (esbit FIFO when running in single-channel mode, see [`CONF.RNG_BIT_ENABLE`](#conf--rng_bit_enable)).
                Entropy bits might get dropped in these locations e.g. due to backpressure from the conditioner.

                Note that the conditioner will still use the amount of bits configured in [`HEALTH_TEST_WINDOWS.FIPS_WINDOW`](#health_test_windows--fips_window) to produce the seed.
                The resulting seed is still okay to use.
                But as the dropped bits are still tested, the effective test window increases beyond the value configured in [`HEALTH_TEST_WINDOWS.FIPS_WINDOW`](#health_test_windows--fips_window).

                Software should check this bit when running in Firmware Override: Observe mode as dropping post-health test entropy bits in this mode may cause the entropy bits observed from the Observe FIFO to be non-contiguous.

                Writing a zero resets this status bit.
                '''
        }
      ]
    },
    {
      name: "ERR_CODE",
      desc: "Hardware detection of error conditions status register",
      swaccess: "ro",
      hwaccess: "hwo",
      fields: [
        { bits: "0",
          name: "SFIFO_ESRNG_ERR",
          desc: '''
                This bit will be set to one when an error has been detected for the
                esrng FIFO. The type of error is reflected in the type status
                bits (bits 28 through 30 of this register).
                This bit will stay set until the next reset.
                '''
        }
        { bits: "1",
          name: "SFIFO_DISTR_ERR",
          desc: '''
                This bit will be set to one when an error has been detected for the distribution FIFO.
                The type of error is reflected in the type status bits (bits 28 through 30 of this register).
                This bit will stay set until the next reset.
                '''
        }
        { bits: "2",
          name: "SFIFO_OBSERVE_ERR",
          desc: '''
                This bit will be set to one when an error has been detected for the
                observe FIFO. The type of error is reflected in the type status
                bits (bits 28 through 30 of this register).
                This bit will stay set until the next reset.
                '''
        }
        { bits: "3",
          name: "SFIFO_ESFINAL_ERR",
          desc: '''
                This bit will be set to one when an error has been detected for the
                esfinal FIFO. The type of error is reflected in the type status
                bits (bits 28 through 30 of this register).
                This bit will stay set until the next reset.
                '''
        }
        { bits: "20",
          name: "ES_ACK_SM_ERR",
          desc: '''
                This bit will be set to one when an illegal state has been detected for the
                ES ack stage state machine. This error will signal a fatal alert, and also
                an interrupt if enabled.
                This bit will stay set until the next reset.
                '''
        }
        { bits: "21",
          name: "ES_MAIN_SM_ERR",
          desc: '''
                This bit will be set to one when an illegal state has been detected for the
                ES main stage state machine. This error will signal a fatal alert, and also
                an interrupt if enabled.
                This bit will stay set until the next reset.
                '''
        }
        { bits: "22",
          name: "ES_CNTR_ERR",
          desc: '''
                This bit will be set to one when a hardened counter has detected an error
                condition. This error will signal a fatal alert, and also
                an interrupt if enabled.
                This bit will stay set until the next reset.
                '''
        }
        { bits: "23",
          name: "SHA3_STATE_ERR",
          desc: '''
                This bit will be set to one when a SHA3 state error has been detected.
                This error will signal a fatal alert, and also an interrupt if enabled.
                This bit will stay set until the next reset.
                '''
        }
        { bits: "24",
          name: "SHA3_RST_STORAGE_ERR",
          desc: '''
                This bit will be set to one when a SHA3_RST_STORAGE_ERR signal being
                active has been detected.
                This error will signal a fatal alert, and also an interrupt if enabled.
                This bit will stay set until the next reset.
                '''
        }
        { bits: "28",
          name: "FIFO_WRITE_ERR",
          desc: '''
                This bit will be set to one when any of the source bits (bits 0 through 3 of this register) are asserted as a result of an error pulse generated from any full FIFO that has been received a write pulse.
                This bit will stay set until the next reset.
                '''
        }
        { bits: "29",
          name: "FIFO_READ_ERR",
          desc: '''
                This bit will be set to one when any of the source bits (bits 0 through 3 of this register) are asserted as a result of an error pulse generated from any empty FIFO that has received a read pulse.
                This bit will stay set until the next reset.
                '''
        }
        { bits: "30",
          name: "FIFO_STATE_ERR",
          desc: '''
                This bit will be set to one when any of the source bits (bits 0 through 3 of this register) are asserted as a result of an error pulse generated from any FIFO where either both the empty and full status bits are set or in case of error conditions inside the hardened counters.
                This bit will stay set until the next reset.
                '''
        }
      ]
    },
    { name: "ERR_CODE_TEST",
      desc: "Test error conditions register",
      swaccess: "rw",
      hwaccess: "hro",
      hwqe: "true",
      tags: [// Setting this register will force an unwanted fatal alert.
                 "excl:CsrNonInitTests:CsrExclWrite"]
      fields: [
        {
            bits: "4:0",
            name: "ERR_CODE_TEST",
            desc: '''
                  Setting this field will set the bit number for which an error
                  will be forced in the hardware. This bit number is that same one
                  found in the !!ERR_CODE register. The action of writing this
                  register will force an error pulse. The sole purpose of this
                  register is to test that any error properly propagates to either
                  an interrupt or an alert.
                  '''
        },
      ]
    },
    { name: "MAIN_SM_STATE",
      desc: "Main state machine state debug register",
      swaccess: "ro",
      hwaccess: "hwo",
      fields: [
        { bits: "8:0",
          name: "MAIN_SM_STATE",
          desc: '''This is the state of the ENTROPY_SRC main state machine.
                See the RTL file `entropy_src_main_sm` for the meaning of the values.
                '''
          resval: 0xf5
        }
      ]
    },
  ]
}
