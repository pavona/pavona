// Copyright lowRISC contributors (OpenTitan project).
// Licensed under the Apache License, Version 2.0, see LICENSE for details.
// SPDX-License-Identifier: Apache-2.0
//
# DOE register template
{
  name:               "mbx"
  human_name:         "DOE Mailbox"
  one_line_desc:      "DOE mailbox for use as an integrated system communication channel"
  one_paragraph_desc: '''
  The SoC (i.e., the SoC Host CPU or other SoC Execution Engines) may request security services from a root-of-trust.
  This means that pre-defined control information must be passed to a root-of-trust from the security service requester.
  A secure inbound/outbound mailbox can be used to implement a secure channel for these request/response transactions between the SoC and the root-of-trust.
  '''
  cip_id:             "37"
  design_spec:        "../doc"
  dv_doc:             "../doc/dv"
  version:            "0.1.0"

  clocking: [{clock: "clk_i", reset: "rst_ni", primary: true}]
  bus_interfaces: [
    { protocol: "tlul", direction: "device", name: "core", hier_path: "u_hostif.u_regs", racl_support: true }
    { protocol: "tlul", direction: "host",   name: "sram" }
    { protocol: "tlul", direction: "device", name: "soc", hier_path: "u_sysif.u_regs", racl_support: true }
  ]
  inter_signal_list: [
    { struct:  "logic",
      type:    "uni",
      name:    "doe_intr_support",
      act:     "req",
      package: "",
      default: "1'b0"
    }
    { struct:  "logic",
      type:    "uni",
      name:    "doe_intr_en",
      act:     "req",
      package: "",
      default: "1'b0"
    }
    { struct:  "logic",
      type:    "uni",
      name:    "doe_intr",
      act:     "req",
      package: "",
      default: "1'b0"
    }
    { struct:  "logic",
      type:    "uni",
      name:    "doe_async_msg_support",
      act:     "req",
      package: "",
      default: "1'b0"
    }
    { struct:  "racl_policy_vec",
      type:    "uni",
      name:    "racl_policies",
      act:     "rcv",
      package: "top_racl_pkg",
      desc:    '''
        Incoming RACL policy vector from a racl_ctrl instance.
        The policy selection vector (parameter) selects the policy for each register.
      '''
    }
    { struct:  "racl_error_log",
      type:    "uni",
      name:    "racl_error",
      act:     "req",
      width:   "1"
      package: "top_racl_pkg",
      desc:    '''
        RACL error log information of this module.
      '''
    }
  ]
  interrupt_list: [
    { name: "mbx_ready"
      desc: "A new object was received in the inbound mailbox."
    }
    { name: "mbx_abort"
      desc: "An abort request was received from the requester."
    }
    { name: "mbx_error"
      desc: "The mailbox instance generated an error."
    }
  ]
  alert_list: [
    { name: "fatal_fault"
      desc: "This fatal alert is triggered when a fatal TL-UL bus integrity fault is detected."
    }
    { name: "recov_fault",
      desc: "This recoverable alert is triggered when memory with invalid ECC (e.g., uninitialized memory) or at an invalid address is accessed."
    }
  ]
  features: [
    {
      name: "MBX.INBOUND"
      desc: '''
        Mailbox can receive inbound messages.
      '''
    }
    {
      name: "MBX.OUTBOUND"
      desc: '''
        Mailbox can transmit outbound messages.
      '''
    }
    {
      name: "MBX.ADDRESS_RANGE"
      desc: '''
        When valid inbound and outbound address ranges are defined,
        the inbound side can declare them valid and optionally lock
        these ranges from subsequent modification.
      '''
    }
    {
      name: "MBX.ABORT"
      desc: '''
        The outbound side can abort a mailbox transaction.
      '''
    }
  ]
  countermeasures: [
    { name: "BUS.INTEGRITY"
      desc: "End-to-end bus integrity scheme."
    }
    { name: "ADDRESS_RANGE.CONFIG.REGWEN_MUBI",
      desc: "Private SRAM memory range is software multibit lockable."
    }
  ]
  regwidth: "32"
  registers: {
    core: [
      { name: "CONTROL"
        desc: "DOE mailbox control register visible to the root-of-trust"
        hwext: "true"
        fields: [
          { name: "abort"
            desc: "Alias of the DoE mailbox abort bit"
            bits: "0"
            resval: "0x0"
            swaccess: "rw"
            hwaccess: "hrw"
            hwqe: "true"
          }
          { name: "error"
            desc: '''
                  Set by firmware to signal an error, e.g. unable to provide a response to request.
                  Set by hardware, on SYS.WDATA or SYS.RDATA performing an invalid access.
                  Cleared by the hardware when SYS sets CONTROL.ABORT.
                  '''
            bits: "1"
            resval: "0x0"
            swaccess: "rw"
            hwaccess: "hrw"
            hwqe: "true"
          }
          { name: "sys_async_msg"
            desc: "Indicates an async message request"
            bits: "3"
            resval: "0x0"
            swaccess: "wo"
            hwaccess: "hro"
            hwqe: "true"
          }
        ]
        tags: ["excl:CsrAllTests:CsrExclAll"] // alias of another register; no automated CSR tests applicable
      }
      { name: "STATUS"
        desc: "DOE mailbox status register visible to the root-of-trust"
        hwext: "true"
        fields: [
          { name: "busy"
            desc: "Alias of the DoE mailbox busy bit"
            bits: "0"
            resval: "0x1"
            swaccess: "ro"
            hwaccess: "hwo"
          }
          { name: "sys_intr_state"
            desc: "Alias of the DoE mailbox interrupt status bit"
            bits: "1"
            resval: "0x0"
            swaccess: "ro"
            hwaccess: "hwo"
          }
          { name: "sys_intr_enable"
            desc: "Alias of the DoE mailbox interrupt enable bit"
            bits: "2"
            resval: "0x0"
            swaccess: "ro"
            hwaccess: "hwo"
          }
          { name: "sys_async_enable"
            desc: "Alias of the DoE mailbox async message support enable bit"
            bits: "3"
            resval: "0x0"
            swaccess: "ro"
            hwaccess: "hwo"
          }
        ]
        tags: ["excl:CsrAllTests:CsrExclAll"] // alias of another register; no automated CSR tests applicable
      }
      { name: "ADDRESS_RANGE_REGWEN"
        desc: "Used to lock the inbound/outbound base/limit configuration registers."
        swaccess: "rw0c"
        hwaccess: "none"
        fields: [
          { name: "regwen"
            desc: '''
                  Once cleared the mailbox inbound/outbound base/limit registers will be locked until the next reset.

                  Default Value = kMultiBitBool4True -> Unlocked at reset.
                  '''
            bits: "3:0"
            mubi: "true"
            resval: true
          }
        ]
        tags: ["excl:CsrNonInitTests:CsrExclAll"] // only check initial value because writing will have side effects
      }
      { name: "ADDRESS_RANGE_VALID"
        desc: "Used to mark the inbound/outbound base/limit configuration registers to have a valid configuration."
        swaccess: "rw"
        hwaccess: "hro"
        hwqe: "true"
        fields: [
          { name: "range_valid"
            desc: "Once set the mailbox inbound/outbound base/limit registers are valid."
            bits: "0"
            resval: "0"
          }
        ]
        tags: ["excl:CsrAllTests:CsrExclAll"] // TODO
      }
      { name: "INBOUND_BASE_ADDRESS"
        desc: '''Base address of SRAM region, which is used to back up the inbound mailbox data.
              This address is 4-byte aligned, the lower 2 bits are ignored.
              '''
        regwen: "ADDRESS_RANGE_REGWEN"
        swaccess: "rw"
        hwaccess: "hro"
        fields: [
          { name: "base_address"
            desc: "Base address of SRAM region, which is used to back up the inbound mailbox data."
            bits: "31:2"
            resval: "0x0"
          }
        ]
      }
      { name: "INBOUND_LIMIT_ADDRESS"
        desc: '''Inclusive end address of the inbound mailbox memory range in the private SRAM.
              This address is 4-byte aligned and it specifies the start address of the final valid
              DWORD location. The lower 2 bits are ignored.
              '''
        regwen: "ADDRESS_RANGE_REGWEN"
        swaccess: "rw"
        hwaccess: "hro"
        fields: [
          { name: "limit"
            desc: "Limit Address to mark the end of the inbound mailbox memory range in the private SRAM."
            bits: "31:2"
            resval: "0x0"
          }
        ]
      }
      { name: "INBOUND_WRITE_PTR"
        desc: '''Write pointer for the next inbound DWORD write (32 bits).
              Pointer is initialized to the Inbox memory base address before the start of a transfer.
              Inbox handler maintains the updated pointer as data DWORDs are received by the DOE inbox.
              This pointer is 4-byte aligned; the lower 2 bits are always zero.
              '''
        hwext: "true"
        fields: [
          { name: "inbound_write_ptr"
            desc: "Write pointer for the next inbound data write."
            bits: "31:2"
            resval: "0x0"
            swaccess: "ro"
            hwaccess: "hwo"
          }
        ]
      }
      { name: "OUTBOUND_BASE_ADDRESS"
        desc: '''Base address of SRAM region, which is used to buffer the outbound mailbox data.
              This address is 4-byte aligned, the lower 2 bits are ignored.
              '''
        regwen: "ADDRESS_RANGE_REGWEN"
        swaccess: "rw"
        hwaccess: "hro"
        fields: [
          { name: "base_address"
            desc: "Base address of SRAM region, which is used to buffer the outbound mailbox data."
            bits: "31:2"
            resval: "0x0"
          }
        ]
      }
      { name: "OUTBOUND_LIMIT_ADDRESS"
        desc: '''Inclusive end address of the outbound mailbox memory range in the private SRAM.
              This address is 4-byte aligned and it specifies the start address of the final valid
              DWORD location. The lower 2 bits are ignored.
              '''
        regwen: "ADDRESS_RANGE_REGWEN"
        swaccess: "rw"
        hwaccess: "hro"
        fields: [
          { name: "limit"
            desc: "Limit Address to mark the end of the outbound mailbox memory range in the private SRAM."
            bits: "31:2"
            resval: "0x0"
          }
        ]
      }
      { name: "OUTBOUND_READ_PTR"
        desc: '''Read pointer for the next outbound DWORD read.
              Pointer is initialized to the Outbox memory base address before the start of an outgoing
              object transfer. Outbox handler maintains the updated pointer as data DWORDs are read
              from the DOE instance by the requester.
              This pointer is 4-byte aligned; the lower 2 bits are always zero.
              '''
        hwext: "true"
        fields: [
          { name: "outbound_read_ptr"
            desc: "Read pointer for the next outbound data read."
            bits: "31:2"
            resval: "0x0"
            swaccess: "ro"
            hwaccess: "hwo"
          }
        ]
      }
      { name: "OUTBOUND_OBJECT_SIZE"
        desc: '''Indicates the size of the data object to be transferred out.
              Note that this size specifies the number of DWORDs (32 bits).
              Maximum size supported by any OT DOE instance is 1024 DWORDs.
              '''
        fields: [
          { name: "cnt"
            desc: "Indicates the size of the data object to be transferred out in 4-byte words."
            bits: "10:0"
            resval: "0x0"
            swaccess: "rw"
            hwaccess: "hrw"
            hwqe: "true"
          }
        ]
      }
      { name: "DOE_INTR_MSG_ADDR"
        desc: '''
              Software read-only alias of the DOE_INTR_MSG_ADDR register of the SoC interface for convenient access of the OT firmware.
              Defined only for FW-to-FW mailboxes.
              '''
        hwext: "true"
        hwaccess: "hwo"
        swaccess: "ro"
        fields: [
          { name: "doe_intr_msg_addr"
            desc: "Utilized by the mailbox responder to send an interrupt message to the requester via a write to the configured address."
            bits: "31:0"
            resval: "0x0"
          }
        ]
        tags: ["excl:CsrAllTests:CsrExclAll"] // alias of another register; no automated CSR tests applicable
      }
      { name: "DOE_INTR_MSG_DATA"
        desc: '''
              Software read-only alias of the DOE_INTR_MSG_DATA register of the SoC interface for convenient access of the OT firmware.
              Defined only for FW-to-FW mailboxes.
              '''
        hwext: "true"
        hwaccess: "hwo"
        swaccess: "ro"
        fields: [
          { name: "doe_intr_msg_data"
            desc: "Interrupt message data to be sent to the address configured in the DOE_INTR_MSG_ADDR register."
            bits: "31:0"
            resval: "0x0"
          }
        ]
        tags: ["excl:CsrAllTests:CsrExclAll"] // alias of another register; no automated CSR tests applicable
      }
    ]
    soc: [
      { skipto: "0x8" }
      { name: "SOC_CONTROL"
        desc: "DOE mailbox control register."
        hwaccess: "hrw"
        hwqe: "true"
        hwext: "true"
        fields: [
          { name: "abort"
            desc: '''
                  A write of 1 to this bit causes all data object transfer operations associated with this DOE instance to be aborted.
                  '''
            bits: "0"
            resval: "0x0"
            swaccess: "wo"
          }
          { name: "doe_intr_en"
            desc: '''
                  If DOE interrupt support is set, when this bit is set and MSI/MSI-X is enabled in MSI capability registers, the DOE instance must issue an MSI/MSI-X interrupt.
                  '''
            bits: "1"
            resval: "0x0"
            swaccess: "rw"
          }
          { name: "doe_async_msg_en"
            desc: '''
                  If DOE Async Message Support is Set, this bit, when Set, enables the use of the DOE Async Message mechanism.
                  When this bit is set, it allows the DOE instance to raise the SOC_STATUS.doe_async_msg_status, indicating an asynchronous message request.
                  '''
            bits: "3"
            resval: "0x0"
            swaccess: "rw"
          }
          { name: "go"
            desc: '''
                  A write of 1 to this bit indicates to the DOE instance that it can start consuming the data object transferred through the DOE Write Data Mailbox register.
                  '''
            bits: "31"
            resval: "0x0"
            swaccess: "wo"
          }
        ]
        tags: ["excl:CsrNonInitTests:CsrExclAll"] // only check initial value because writing will have side effects
      }
      { name: "SOC_STATUS"
        desc: "DOE mailbox status register"
        fields: [
          { name: "busy"
            desc: '''
                  When Set, this bit indicates the DOE instance is temporarily unable to receive a new data object through the DOE Write Data Mailbox register.
                  This bit is also set by the DOE instance when processing an abort command and remains set until abort handling is complete.
                  '''
            bits: "0"
            resval: "0x1"
            swaccess: "ro"
            hwaccess: "hrw"
          }
          { name: "doe_intr_status"
            desc: "This bit is set when an interrupt event occurs. Writing a value of 1 to this bit clears the status bit."
            bits: "1"
            resval: "0x0"
            swaccess: "rw1c"
            hwaccess: "hrw"
          }
          { name: "error"
            desc: '''
                  When Set, this bit indicates that there has been an internal error associated with data object received, or that a data object has been received for which the DOE instance is unable to provide a response.
                  The transition of this bit from Clear to Set is an interrupt-triggering event.
                  '''
            bits: "2"
            resval: "0x0"
            swaccess: "ro"
            hwaccess: "hrw"
          }
          { name: "doe_async_msg_status"
            desc: '''
                  This bit, when Set, indicates the DOE instance has one or more asynchronous messages to transfer.
                  The transition of this bit from Clear to Set is an interrupt-triggering event.
                  This bit is set when an interrupt event occurs.
                  '''
            bits: "3"
            resval: "0x0"
            swaccess: "ro"
            hwaccess: "hwo"
          }
          { name: "ready"
            desc: '''
                  When Set, this bit indicates the DOE instance has a data object available to be read by SoC firmware/software.
                  The transition of this bit from Clear to Set is an interrupt-triggering event.
                  '''
            bits: "31"
            resval: "0x0"
            swaccess: "ro"
            hwaccess: "hrw"
          }
        ]
        tags: ["excl:CsrAllTests:CsrExclAll"] // TODO
      }
      { window: {
          name: "WDATA"
          items: "1"
          swaccess: "rw"
          desc: '''DOE mailbox write data register.
                The DOE instance receives data objects via writes to this register.
                A successful write adds one DWORD to the data object being assembled in the DOE instance.
                A write of 1 to the DOE Go bit in the DOE Control Register marks the completion of the data transfer, i.e, final DWORD for the object has been written.
                '''
        }
      }
      { window: {
          name: "RDATA"
          desc: '''DOE mailbox read data register
                If the Data Object Ready bit is Set, a read of this register returns the current DWORD of the data object.
                A write of any value to this register indicates a successful read of the current DWORD.
                The next read to this register shall return the next DWORD from the data object being read.
                If Data Object Ready bit is clear, writes of any value to this register must have no effect and reads from this register return zero.
                '''
          items: "1"
          swaccess: "rw"
        }
      }
      { name: "SOC_DOE_INTR_MSG_ADDR"
        desc: '''
              Utilized by the mailbox responder to send an interrupt message to the requester via a write to the configured address.
              Defined only for FW-to-FW mailboxes.
              '''
        swaccess: "rw"
        hwaccess: "hro"
        fields: [
          { name: "doe_intr_msg_addr"
            desc: "Utilized by the mailbox responder to send an interrupt message to the requester via a write to the configured address."
            bits: "31:0"
            resval: "0x0"
          }
        ]
      }
      { name: "SOC_DOE_INTR_MSG_DATA"
        desc: '''
              Interrupt message data to be sent to the address configured in the DOE_INTR_MSG_ADDR register.
              Defined only for FW-to-FW mailboxes.
              '''
        swaccess: "rw"
        hwaccess: "hro"
        fields: [
          { name: "doe_intr_msg_data"
            desc: "Interrupt message data to be sent to the address configured in the DOE_INTR_MSG_ADDR register."
            bits: "31:0"
            resval: "0x0"
          }
        ]
      }
    ]
  }
}
