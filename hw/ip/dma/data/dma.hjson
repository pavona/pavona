// Copyright lowRISC contributors (OpenTitan project).
// Licensed under the Apache License, Version 2.0, see LICENSE for details.
// SPDX-License-Identifier: Apache-2.0
//
# DMA register template
{
  name:               "dma"
  human_name:         "DMA Controller"
  one_line_desc:      "DMA Controller for integrated systems"
  one_paragraph_desc: '''
  The secure DMA controller provides the ability to move data blobs securely in and out of secure memory while offloading the Ibex core to focus on security critical tasks.
  The secure DMA provides an hardware isolation layer between secure memory and the rest of the SoC.
  It provides the hardware enforcement of security properties through well defined isolation & access control techniques, hardware based checking and other protection mechanisms.
  Note that depending upon use case, it is expected that the SoC provides proper security mechanisms for code / data protections such as access control mechanisms, encrypted (w/integrity protection) memory regions etc.
  '''
  cip_id:             "36",
  design_spec:        "../doc"
  dv_doc:             "../doc/dv"
  version:            "2.0.0"

  clocking: [
    {clock: "clk_i", reset: "rst_ni", primary: true},
    {clock: "clk_edn_i", reset: "rst_edn_ni"}
  ]
  scan: "true"        // Enable `scanmode_i` port
  bus_interfaces: [
    { protocol: "tlul", direction: "device", hier_path: "u_dma_reg", racl_support: true }
    { protocol: "tlul", direction: "host", name: "host32", count: "NumTlul32" }
  ]
  param_list: [
    { name: "NumIntClearSources",
      desc: "Number of interrupt clearing sources to process",
      type: "int",
      default: "11",
      local: "true"
    },
    { name: "EnableDataIntgGen",
      desc: "Compute integrity bits for A channel data on all TL-UL host ports",
      type: "bit",
      default: "1'b1",
      local: "false",
      expose: "true",
    },
    { name: "EnableRspDataIntgCheck",
      desc: "Enable integrity checks on the response TL-UL D channel",
      type: "bit",
      default: "1'b1",
      local: "false",
      expose: "true",
    },
    { name: "NumPorts",
      desc: "Total number of host data ports. Override together with DmaPortDesc."
      type: "int",
      default: "3",
      local: "false",
      expose: "true",
    },
    { name:                "PortDesc",
      desc:                '''Generic host port descriptor array.
                           Top-level connection to the host ports must follow this definition.
                           '''
      type:                "dma_pkg::dma_port_desc_t"
      // unpacked_dimensions is emitted verbatim by topgen, so use the top-prefixed count name.
      unpacked_dimensions: "[DmaNumPorts]"
      default:             "'{dma_pkg::DmaPortOtInternal, dma_pkg::DmaPortSocControl, dma_pkg::DmaPortSocSystem}"
      local:               "false",
      expose:              "true",
    },
    { name: "NumTlul32",
      desc: "Number of 32-bit TLUL host ports. Per-index routing (xbar vs point-to-point) is resolved at the top level."
      type: "int unsigned"
      default: "2",
      local: "false",
      expose: "true",
    },
    { name: "NumTlul64",
      desc: "Number of 64-bit TLUL host ports (off-bus, point-to-point)."
      type: "int unsigned"
      default: "1",
      local: "false",
      expose: "true",
    },
    { name: "NumAadWords",
      desc: "Number of 32-bit AAD words exposed for inline AES-GCM (AAD-from-CSR)."
      type: "int"
      default: "8",
      local: "true"
    },
    { name: "SecAesMasking",
      desc: "Enable (1) first-order masking of the inline AES datapath; 0 ties off EDN (non-production)."
      type: "bit",
      default: "1'b1",
      local: "false",
      expose: "true",
    },
    # Random netlist constants for the inline-AES clearing/masking PRNGs (threaded into aes_core).
    { name:    "RndCnstClearingLfsrSeed",
      type:    "aes_pkg::clearing_lfsr_seed_t",
      desc:    "Default seed of the inline-AES PRNG used for register clearing."
      randcount: "64",
      randtype:  "data"
    },
    { name:    "RndCnstClearingLfsrPerm",
      type:    "aes_pkg::clearing_lfsr_perm_t",
      desc:    "Permutation applied to the LFSR of the inline-AES clearing PRNG."
      randcount: "64",
      randtype:  "perm"
    },
    { name:    "RndCnstClearingSharePerm",
      type:    "aes_pkg::clearing_lfsr_perm_t",
      desc:    "Permutation applied to the clearing PRNG output for clearing the second share."
      randcount: "64",
      randtype:  "perm"
    },
    { name:    "RndCnstMaskingLfsrSeed",
      type:    "aes_pkg::masking_lfsr_seed_t",
      desc:    "Default seed of the inline-AES PRNG used for masking."
      randcount: "288",
      randtype:  "data"
    },
    { name:    "RndCnstMaskingLfsrPerm",
      type:    "aes_pkg::masking_lfsr_perm_t",
      desc:    "Permutation applied to the output of the inline-AES masking PRNG."
      randcount: "160",
      randtype:  "perm"
    },
  ],
  inter_signal_list: [
    { name: "lsio_trigger"
      type: "uni",
      act: "rcv",
      package: "dma_pkg",
      struct: "lsio_trigger",
      width: "1"
    }
    // Inline AES inter-signals (mirror the AES IP).
    { struct:  "lc_tx"
      type:    "uni"
      name:    "lc_escalate_en"
      act:     "rcv"
      default: "lc_ctrl_pkg::Off"
      package: "lc_ctrl_pkg"
    }
    { struct:  "edn"
      type:    "req_rsp"
      name:    "edn"
      act:     "req"
      package: "edn_pkg"
    }
    { struct:  "hw_key_req"
      type:    "uni"
      name:    "keymgr_key"
      act:     "rcv"
      default: "keymgr_pkg::HW_KEY_REQ_DEFAULT"
      package: "keymgr_pkg"
    }
    { struct:  "dma_tl_h2d"
      package: "dma_tlul_pkg"
      type:    "uni"
      name:    "host64_h2d"
      act:     "req"
      width:   "NumTlul64"
      desc:    "64-bit TLUL host (h2d) to chip top, point-to-point"
    }
    { struct:  "tl_d2h"
      package: "tlul_pkg"
      type:    "uni"
      name:    "host64_d2h"
      act:     "rcv"
      width:   "NumTlul64"
      desc:    "64-bit TLUL host (d2h) from chip top, point-to-point"
    }
    { struct:  "racl_policy_vec",
      type:    "uni",
      name:    "racl_policies",
      act:     "rcv",
      package: "top_racl_pkg",
      desc:    '''
        Incoming RACL policy vector from a racl_ctrl instance.
        The policy selection vector (parameter) selects the policy for each register.
      '''
    }
    { struct:  "racl_error_log",
      type:    "uni",
      name:    "racl_error",
      act:     "req",
      width:   "1"
      package: "top_racl_pkg",
      desc:    '''
        RACL error log information of this module.
      '''
    }
  ]
  interrupt_list: [
    { name: "dma_done"
      desc: "DMA operation has been completed."
      type: "status"
    }
    { name: "dma_chunk_done"
      desc: "Indicates the transfer of a single chunk has been completed."
      type: "status"
    }
    { name: "dma_error"
      desc: "DMA error has occurred. DMA_STATUS.error_code register shows the details."
      type: "status"
    }
  ]
  alert_list: [
    { name: "fatal_fault"
      desc: '''
            This fatal alert is triggered when a fatal TL-UL bus integrity fault is detected, or on
            an inline-AES fatal fault (aes_core fatal alert or the AES-wrapper sparse-FSM error).
            '''
    }
    { name: "recov_fault"
      desc: '''
            This recoverable alert is triggered on an inline AES-GCM decrypt authentication tag
            mismatch, or on an aes_core recoverable fault.
            '''
    }
  ]
  countermeasures: [
    { name: "BUS.INTEGRITY",
      desc: "End-to-end bus integrity scheme."
    }
    { name: "ASID.INTERSIG.MUBI",
      desc: "Destination and source ASID signals are multibit encoded."
    }
    { name: "LC_ESCALATE_EN.INTERSIG.MUBI",
      desc: "Life-cycle escalation input to the inline AES is multibit encoded and synchronized."
    }
    { name: "RANGE.CONFIG.REGWEN_MUBI",
      desc: "DMA enabled memory range is software multibit lockable."
    }
    { name: "FSM.SPARSE",
      desc: "The main `ctrl_state` FSM is sparsely encoded."
    }
    { name: "AES.FSM.SPARSE",
      desc: "The inline-AES wrapper (`dma_aes`) sub-FSM is sparsely encoded."
    }
    { name: "KEY.SIDELOAD",
      desc: "Inline AES can source its key from the keymgr sideload interface."
    }
    { name: "KEY.SW_UNREADABLE",
      desc: "Inline AES KEY_SHARE and TAG_IN registers are write-only."
    }
    { name: "KEY.SEC_WIPE",
      desc: "Inline AES key/IV/tag material is wiped after use (tracked)."
    }
    { name: "CTRL.CONSISTENCY",
      desc: "Inline AES-GCM decrypt tag compare is glitch-resistant and fail-closed."
    }
  ]
  regwidth: "32"
  registers: [
    { name: "SRC_ADDR_LO"
      desc: '''
            Lower 32 bits of the physical or virtual address of memory location within SoC memory address map or physical address within non-secure memory space.
            Data is read from this location in a copy operation.
            The address may be an IO virtual address.
            Must be aligned to the transfer width.
            '''
      swaccess: "rw"
      hwaccess: "hrw"
      regwen: "CFG_REGWEN"
      fields: [
        { bits: "31:0"
          name: "src_addr_lo"
          resval: 0x0
          desc: '''Lower 32 bits of the source address.
                Must be aligned to the transfer width.
                '''
        }
      ]
    }
    { name: "SRC_ADDR_HI"
      desc: '''Upper 32 bits of the source address.
            Must be aligned to the transfer width.
            Source and destination address must have the same alignment.
            '''
      swaccess: "rw"
      hwaccess: "hrw"
      regwen: "CFG_REGWEN"
      fields: [
        { bits: "31:0"
          name: "src_addr_hi"
          resval: 0x0
          desc: '''
                Upper 32 bits of the physical or virtual address of memory location within SoC memory address map or physical address within non-secure memory space.
                Must be aligned to the transfer width.
                Source and destination address must have the same alignment.
                '''
        }
      ]
    }
    { name: "DST_ADDR_LO"
      desc: '''
            Lower 32 bits of the physical or virtual address of memory location within SoC memory address map or physical address within non-secure memory space.
            Data is written to this location in a copy operation.
            The address may be an IO virtual address.
            Must be aligned to the transfer width.
            Source and destination address must have the same alignment.
            '''
      swaccess: "rw"
      hwaccess: "hrw"
      regwen: "CFG_REGWEN"
      fields: [
        { bits: "31:0"
          name: "dst_addr_lo"
          resval: 0x0
          desc: '''Lower 32 bits of the destination address.
                Must be aligned to the transfer width.
                Source and destination address must have the same alignment.
                '''
        }
      ]
    }
    { name: "DST_ADDR_HI"
      desc: '''Upper 32 bits of the destination address.
            Must be aligned to the transfer width.
            Source and destination address must have the same alignment.
            '''
      swaccess: "rw"
      hwaccess: "hrw"
      regwen: "CFG_REGWEN"
      fields: [
        { bits: "31:0"
          name: "dst_addr_hi"
          resval: 0x0
          desc: '''
                Upper 32 bits of the physical or virtual address of memory location within SoC memory address map or physical address within non-secure memory space.
                Must be aligned to the transfer width.
                Source and destination address must have the same alignment.
                '''
        }
      ]
    }
    { name: "ADDR_SPACE_ID"
      desc: "Encoded source/destination port IDs. Only IDs configured in PortDesc are accepted; zero and all-ones are invalid. Encodings have minimum Hamming distance four."
      swaccess: "rw"
      hwaccess: "hro"
      regwen: "CFG_REGWEN"
      fields: [
        { bits: "7:0"
          name: "src_asid"
          resval: 0x03
          desc: "Target address space that the source address pointer refers to."
          enum: [
            { value: "0x03"
              name: "OT_ADDR"
              desc: "Secure 32-bit internal bus."
            }
            { value: "0x0c"
              name: "SOC_ADDR"
              desc: "SoC control register bus using 32-bit (or 64 bits if configured by an SoC) control port."
            }
            { value: "0x30"
              name: "SYS_ADDR"
              desc: "SoC system address bus using 64 bit SYS port."
            }
            { value: "0x3f", name: "ASID_3", desc: "Reserved unless assigned in the port descriptors." }
            { value: "0x56", name: "ASID_4", desc: "Reserved unless assigned in the port descriptors." }
            { value: "0x59", name: "ASID_5", desc: "Reserved unless assigned in the port descriptors." }
            { value: "0x65", name: "ASID_6", desc: "Reserved unless assigned in the port descriptors." }
            { value: "0x6a", name: "ASID_7", desc: "Reserved unless assigned in the port descriptors." }
            { value: "0x95", name: "ASID_8", desc: "Reserved unless assigned in the port descriptors." }
            { value: "0x9a", name: "ASID_9", desc: "Reserved unless assigned in the port descriptors." }
            { value: "0xa6", name: "ASID_10", desc: "Reserved unless assigned in the port descriptors." }
            { value: "0xa9", name: "ASID_11", desc: "Reserved unless assigned in the port descriptors." }
            { value: "0xc0", name: "ASID_12", desc: "Reserved unless assigned in the port descriptors." }
            { value: "0xcf", name: "ASID_13", desc: "Reserved unless assigned in the port descriptors." }
            { value: "0xf3", name: "ASID_14", desc: "Reserved unless assigned in the port descriptors." }
            { value: "0xfc", name: "ASID_15", desc: "Reserved unless assigned in the port descriptors." }
          ]
        }
        { bits: "15:8"
          name: "dst_asid"
          resval: 0x03
          desc: "Target address space that the destination address pointer refers to."
          enum: [
            { value: "0x03"
              name: "OT_ADDR"
              desc: "Secure 32-bit internal bus."
            }
            { value: "0x0c"
              name: "SOC_ADDR"
              desc: "SoC control register bus using 32-bit (or 64 bits if configured by an SoC) control port."
            }
            { value: "0x30"
              name: "SYS_ADDR"
              desc: "SoC system address bus using 64 bit SYS port."
            }
            { value: "0x3f", name: "ASID_3", desc: "Reserved unless assigned in the port descriptors." }
            { value: "0x56", name: "ASID_4", desc: "Reserved unless assigned in the port descriptors." }
            { value: "0x59", name: "ASID_5", desc: "Reserved unless assigned in the port descriptors." }
            { value: "0x65", name: "ASID_6", desc: "Reserved unless assigned in the port descriptors." }
            { value: "0x6a", name: "ASID_7", desc: "Reserved unless assigned in the port descriptors." }
            { value: "0x95", name: "ASID_8", desc: "Reserved unless assigned in the port descriptors." }
            { value: "0x9a", name: "ASID_9", desc: "Reserved unless assigned in the port descriptors." }
            { value: "0xa6", name: "ASID_10", desc: "Reserved unless assigned in the port descriptors." }
            { value: "0xa9", name: "ASID_11", desc: "Reserved unless assigned in the port descriptors." }
            { value: "0xc0", name: "ASID_12", desc: "Reserved unless assigned in the port descriptors." }
            { value: "0xcf", name: "ASID_13", desc: "Reserved unless assigned in the port descriptors." }
            { value: "0xf3", name: "ASID_14", desc: "Reserved unless assigned in the port descriptors." }
            { value: "0xfc", name: "ASID_15", desc: "Reserved unless assigned in the port descriptors." }
          ]
        }
      ]
    }
    { name: "ENABLED_MEMORY_RANGE_BASE"
      desc: "Base Address to mark the start of the DMA enabled memory range within the secure internal memory space."
      swaccess: "rw"
      hwaccess: "hro"
      hwqe: "true"
      regwen: "RANGE_REGWEN"
      fields: [
        { bits: "31:0"
          name: "base"
          resval: 0x0
          desc: "Base Address to mark the start of the DMA enabled memory range within the secure internal memory space."
        }
      ]
      tags: ["excl:CsrAllTests:CsrExclWrite"]
    }
    { name: "ENABLED_MEMORY_RANGE_LIMIT"
      desc: "Limit Address to mark the end of the DMA enabled memory range within the secure internal memory space; address is inclusive."
      swaccess: "rw"
      hwaccess: "hro"
      hwqe: "true"
      regwen: "RANGE_REGWEN"
      fields: [
        { bits: "31:0"
          name: "limit"
          resval: 0x0
          desc: "Limit Address to mark the end of the DMA enabled memory range within the secure internal memory space; inclusive."
        }
      ]
      tags: ["excl:CsrAllTests:CsrExclWrite"]
    }
    { name: "RANGE_VALID"
      desc: "Indicates that the ENABLED_MEMORY_RANGE_BASE and _LIMIT registers have been programmed to restrict DMA accesses within the secure internal address space."
      swaccess: "rw"
      hwaccess: "hro"
      regwen: "RANGE_REGWEN"
      fields: [
        { name: "range_valid"
          desc: "Once set the enabled memory base and limit registers are valid."
          bits: "0"
          resval: "0"
        }
      ]
      tags: ["excl:CsrAllTests:CsrExclWrite"]
    }
    { name: "RANGE_REGWEN"
      desc: "Used to lock the DMA enabled memory range configuration registers."
      swaccess: "rw0c"
      hwaccess: "hro"
      fields: [
        { bits: "3:0"
          mubi: "true"
          name: "regwen"
          resval: true
          desc: '''
                Used by firmware to lock the DMA enabled memory range configuration registers from further modification.
                Once this register is set to kMultiBitBool4False, it can only be set to kMultiBitBool4True through a reset event.

                Default Value = kMultiBitBool4True -> Unlocked at reset.
                '''
        }
      ]
      // Don't let automated CSR tests write random values to this register, as it could lock
      // writing to other registers, which the automated tests are not aware of.
      tags: ["excl:CsrAllTests:CsrExclWrite"]
    }
    { name: "CFG_REGWEN"
      desc: '''
            Indicates whether the configuration registers are locked because the DMA controller is operating.
            In the idle state, this register is set to kMultiBitBool4True unless an AES message
            is suspended between chunks. AES keeps the configuration locked until completion,
            abort, or error; CONTROL and STATUS remain usable to resume or abort the message.
            When the DMA is performing an operation, i.e. the DMA is busy, this register is set to kMultiBitBool4False.
            During the DMA operation, the CONTROL and STATUS registers remain usable.
            The comportable registers (the interrupt and alert configuration) are NOT locked during the DMA operation and can still be updated.
            When the DMA reaches an interrupt or alert condition, it will perform the action according to the current register configuration.
            '''
      swaccess: "ro"
      hwaccess: "hwo"
      hwext: "true"
      fields: [
        { bits: "3:0"
          mubi: "true"
          resval: true
          name: "regwen"
          desc: '''
                Used by hardware to lock the DMA configuration registers.
                This register is purely managed by hardware and only software readable.
                '''
        }
      ]
      // Don't let automated CSR tests write random values to this register, as it could lock
      // writing to other registers, which the automated tests are not aware of.
      tags: ["excl:CsrAllTests:CsrExclWrite"]
    }
    { name: "TOTAL_DATA_SIZE"
      desc: "Total size (in bytes) of the data to be transferred."
      swaccess: "rw"
      hwaccess: "hro"
      regwen: "CFG_REGWEN"
      fields: [
        { bits: "31:0"
          name: "data_size"
          resval: 0x0
          desc: '''
                Total size (in bytes) of the data to be transferred. The complete transfer operation
                may consist of multiple chunks of data as specified by the CHUNK_DATA_SIZE register.

                Minimum: 1 byte.
                Maximum: May be restricted to a maximum pre-defined size based on DMA enabled memory space allocation.
                Works in conjunction with the TRANSFER_WIDTH register.
                '''
        }
      ]
    }
    { name: "CHUNK_DATA_SIZE"
      desc: "Number of bytes to be transferred in response to each interrupt/firmware request."
      swaccess: "rw"
      hwaccess: "hro"
      regwen: "CFG_REGWEN"
      fields: [
        { bits: "31:0"
          name: "data_size"
          resval: 0x0
          desc: '''
                Size (in bytes) for a single DMA transfer.
                In hardware handshake mode, the DMA reads in chunks of CHUNK_DATA_SIZE from the peripheral.
                For a single memory transfer CHUNK_DATA_SIZE and TOTAL_DATA_SIZE are set to the same value.

                Minimum: 1 byte.
                Maximum: May be restricted to a maximum pre-defined size based on DMA enabled memory space allocation.
                Works in conjunction with the TRANSFER_WIDTH register.
                '''
        }
      ]
    }
    { name: "TRANSFER_WIDTH"
      desc: "Denotes the width of each transaction that the DMA shall issue."
      swaccess: "rw"
      hwaccess: "hro"
      regwen: "CFG_REGWEN"
      fields: [
        { bits: "1:0"
          name: "transaction_width"
          resval: 0x2
          desc: '''
                Denotes the width of each transaction that the DMA shall issue during the data movement.

                Multiple transactions of this width will be issued until TOTAL_DATA_SIZE bytes have been transferred.
                Note that firmware may need to set a different value if a receiving IP supports a read / write transaction width that is less than 1 DWORD.
                This does not affect the wrap-around mechanism.
                Note that the value 3 for this register represents an invalid configuration that leads to an error.
                '''
          enum: [
            { value: "0",
              name: "ONE_BYTE"
              desc: "One byte per transaction."
            }
            { value: "1",
              name: "TWO_BYTE",
              desc: "Two bytes per transaction."
            }
            { value: "2",
              name: "FOUR_BYTE",
              desc: '''
                    Four bytes per transaction.
                    Default value after reset.
                    '''
            }
          ]
        }
      ]
    }
    { name: "CONTROL"
      desc: "Control register for DMA data movement."
      swaccess: "rw"
      hwaccess: "hro"
      fields: [
        { bits: "0"
          name: "read_en"
          resval: 0x1
          desc: '''
                1 = read from source memory; 0 = memset (write data taken from SRC_ADDR_LO pattern).
                '''
        }
        { bits: "1"
          name: "write_en"
          resval: 0x1
          desc: '''
                1 = write to destination; 0 = verify (digest-only, no write).
                '''
        }
        { bits: "3:2"
          name: "digest"
          resval: 0x0
          desc: '''
                Selects the inline hashing digest computed over the moved data.
                '''
          enum: [
            { value: "0",
              name: "NONE"
              desc: "No inline hashing."
            }
            { value: "1",
              name: "SHA256"
              desc: "Perform inline hashing using SHA256."
            }
            { value: "2",
              name: "SHA384"
              desc: "Perform inline hashing using SHA384."
            }
            { value: "3",
              name: "SHA512"
              desc: "Perform inline hashing using SHA512."
            }
          ]
        }
        { bits: "11:10"
          name: "aes_op"
          resval: 0x0
          desc: '''
                Inline AES cipher operation. Plain encoding (no fault hardening, consistent with the
                rest of CONTROL; if FI protection is required this register would be shadowed). The
                reserved value raises an opcode error. Mutually exclusive with the digest field.
                '''
          enum: [
            { value: "0",
              name: "OFF"
              desc: "No inline AES cipher operation."
            }
            { value: "1",
              name: "ENC"
              desc: "AES encrypt (CIPH_FWD)."
            }
            { value: "2",
              name: "DEC"
              desc: "AES decrypt (CIPH_INV)."
            }
          ]
        }
        { bits: "12"
          name: "aes_mode"
          resval: 0x0
          desc: '''
                Inline AES block-cipher mode; only meaningful when aes_op != OFF.
                0 = AES-CTR, 1 = AES-GCM.
                '''
        }
        { bits: "4"
          name: "hardware_handshake_enable"
          resval: 0x0
          desc: '''
                Enable hardware handshake mode.
                Used to clear FIFOs from low speed IO peripherals receiving data, e.g., I3C receive buffer.
                  Listen to an input trigger signal.
                  Read data from source address location.
                  Copy to destination address.
                  Number of bytes specified in size register.
                  Note assumption is the peripheral lowers input once FIFO is cleared.
                No explicit clearing necessary.
                '''
        }
        { bits: "5"
          name: "digest_swap"
          resval: 0x0
          desc: '''Digest register byte swap.

                If 1 the value in each digest output register is converted to big-endian byte order.
                This setting does not affect the order of the digest output registers, !!SHA2_DIGEST_0 still contains the first 4 bytes of the digest.
                '''
        }
        { bits: "8"
          name: "initial_transfer"
          resval: 0x0
          hwaccess: "hrw"
          desc: '''
                Marks the initial transfer to initialize the DMA and SHA engine for one transfer that can span over multiple single DMA transfers.
                Used for hardware handshake and ordinary transfers, in which multiple transfers contribute to a final digest.
                Note, for non-handshake transfers with inline hashing mode enabled, this bit must be set to also mark the first transfer.
                '''
        }
        { bits: "27"
          name: "abort"
          swaccess: "wo"
          hwaccess: "hrw"
          resval: 0x0
          desc: '''
                Aborts the DMA operation if this bit is set.
                Sets the corresponding bit in the status register once abort operation is complete.
                Any secure-side internal transactions are guaranteed to complete, but there are no guarantees on the SoC interface.
                '''
        }
        { bits: "31"
          name: "go"
          resval: 0x0
          hwaccess: "hrw"
          hwqe: "true"
          desc: '''
                Setting this bit triggers the DMA operation.
                For normal operation, the DMA engine clears the `go` bit automatically after the configured operation is complete.
                For Hardware handshake operation, DMA engine does not auto clear the Go bit.
                Firmware shall clear the Go bit when it intends to stop the hardware handshake operation.
                '''
        }
      ]
      // Don't let automated CSR tests write random values to this register, as it could have side
      // effects (e.g., starting an operation when the `go` bit is written) which the automated
      // tests are not aware of.
      tags: ["excl:CsrAllTests:CsrExclWrite"]
    }
    {
      name: "SRC_CONFIG"
      desc: "Defines the addressing behavior of the DMA for the source address."
      swaccess: "rw"
      hwaccess: "hro"
      regwen: "CFG_REGWEN"
      fields: [
        { bits: "1"
          name: "wrap"
          resval: 0x0
          desc: '''
                When 0: Chunks occupy contiguous ascending addresses.
                When 1: Source address wraps back to the starting address when finishing a chunk.
                '''
        }
        { bits: "0"
          name: "increment"
          resval: 0x0
          desc: '''
                Defines the increment behavior after every DMA read.
                When 0: Source address is not changed.
                        All reads are done from the same address.
                When 1: Source address is incremented by transfer_width after each read.
                '''
        }
      ]
    }
    {
      name: "DST_CONFIG"
      desc: "Defines the addressing behavior of the DMA for the destination address."
      swaccess: "rw"
      hwaccess: "hro"
      regwen: "CFG_REGWEN"
      fields: [
        { bits: "1"
          name: "wrap"
          resval: 0x0
          desc: '''
                When 0: Chunks occupy contiguous ascending addresses.
                When 1: Destination address wraps back to the starting address when finishing a chunk.
                '''
        }
        { bits: "0"
          name: "increment"
          resval: 0x0
          desc: '''
                Defines the increment behavior after every DMA write.
                When 0: Destination address is not changed.
                        All writes are done to the same address.
                When 1: Destination address is incremented by transfer_width after each write.
                '''
        }
      ]
    }
    { name: "STATUS"
      desc: "Status indication for DMA data movement."
      swaccess: "rw1c"
      hwaccess: "hwo"
      fields: [
        { bits: "0"
          name: "busy"
          resval: 0x0
          hwaccess: "hrw"
          swaccess: "ro"
          desc: '''
                DMA operation is active if this bit is set.
                DMA engine clears this bit when operation is complete.
                This bit may be set as long as hardware handshake mode is active and triggered.
                '''
        }
        { bits: "1"
          name: "done"
          resval: 0x0
          hwaccess: "hrw"
          desc: '''
                Configured DMA operation is complete.
                Cleared automatically by the hardware when starting a new transfer.
                '''
        }
        { bits: "2"
          name: "aborted"
          resval: 0x0
          desc: "Set once aborted operation drains."
        }
        { bits: "3"
          name: "error"
          resval: 0x0
          hwaccess: "hrw"
          hwqe: "true"
          desc: '''
                Error occurred during the operation.
                ERROR_CODE register denotes the source of the error.
                '''
        }
        { bits: "4"
          name: "sha2_digest_valid"
          swaccess: "ro"
          resval: 0x0
          hwaccess: "hrw"
          hwqe: "true"
          desc: '''
                Indicates whether the SHA2_DIGEST register contains a valid digest.
                This value is cleared on the initial transfer and set when the digest is written.
                '''
        }
        { bits: "5"
          name: "chunk_done"
          resval: 0x0
          hwaccess: "hrw"
          desc: '''
                Transfer of a single chunk is complete.
                Only raised for multi-chunk memory-to-memory transfers.
                Cleared automatically by the hardware when starting the transfer of a new chunk.
                '''
        }
        { bits: "6"
          name: "tag_valid"
          swaccess: "ro"
          resval: 0x0
          hwaccess: "hrw"
          hwqe: "true"
          desc: '''
                Inline AES-GCM: the computed authentication tag (encrypt) is valid in TAG_OUT, or
                the supplied tag matched (decrypt). Cleared on the initial transfer and set by
                hardware on clean completion.
                '''
        }
        { bits: "7"
          name: "tag_failed"
          swaccess: "ro"
          resval: 0x0
          hwaccess: "hrw"
          hwqe: "true"
          desc: '''
                Inline AES-GCM decrypt: the supplied authentication tag did NOT match. When set,
                the DMA done indication is suppressed, but the DMA does not hardware-quarantine
                the destination: plaintext was written before authentication and may already be
                visible to other bus masters. Every consumer must wait for tag_valid; on failure,
                software must wipe the destination before reuse. Cleared on the initial transfer.
                '''
        }
      ]
    }
    { name: "ERROR_CODE"
      desc: '''
            Denotes the source of the operational error.
            The error is cleared by writing the RW1C STATUS.error register.
            '''
      swaccess: "ro"
      hwaccess: "hwo"
      fields: [
        { bits: "0"
          name: "src_addr_error"
          resval: 0x0
          desc: "Source address is invalid."
        }
        { bits: "1"
          name: "dst_addr_error"
          resval: 0x0
          desc: "Destination address is invalid."
        }
        { bits: "2"
          name: "opcode_error"
          resval: 0x0
          desc: "Opcode is invalid."
        }
        { bits: "3"
          name: "size_error"
          resval: 0x0
          desc: "TRANSFER_WIDTH encodes an invalid value, TOTAL_DATA_SIZE or CHUNK_SIZE are zero, or inline hashing is not using 32-bit transfer width"
        }
        { bits: "4"
          name: "bus_error"
          resval: 0x0
          desc: "The bus transfer returned an error."
        }
        { bits: "5"
          name: "base_limit_error"
          resval: 0x0
          desc: "The base and limit addresses contain an invalid value."
        }
        { bits: "6"
          name: "range_valid_error"
          resval: 0x0
          desc: "The DMA enabled memory range is not configured."
        }
        { bits: "7"
          name: "asid_error"
          resval: 0x0
          desc: "The source or destination ASID contains an invalid value."
        }
        { bits: "8"
          name: "aes_tag_error"
          resval: 0x0
          desc: "Inline AES-GCM decrypt authentication tag mismatch."
        }
      ]
    }
    { multireg: {
        name: "SHA2_DIGEST"
        cname: "DMA"
        desc: '''
              Digest register for the inline hashing operation.
              Depending on the used hashing mode, not all registers are used.
                SHA256: Digest is stored in registers 0 to 7
                SHA384: Digest is stored in registers 0 to 11
                SHA512: Digest is stored in registers 0 to 15
              '''
        count: "16"
        swaccess: "ro",
        hwaccess: "hwo",
        fields: [
          { name: "data"
            desc: "SHA2 digest data"
            bits: "31:0"
            resval: "0"
          }
        ]
      }
    }
    { name: "HANDSHAKE_INTR_ENABLE"
      desc: "Enable bits for incoming handshake interrupt wires."
      swaccess: "rw"
      hwaccess: "hro"
      regwen: "CFG_REGWEN"
      fields: [
        { bits: "NumIntClearSources-1:0"
          name: "mask"
          resval: "0x7FF"
          desc: "Enable bits for incoming handshake interrupt wires."
        }
      ]
    }
    { name: "CLEAR_INTR_SRC"
      desc: '''
            Valid bits for which interrupt sources need clearing.
            When HANDSHAKE_INTR_ENABLE is non-zero and corresponding lsio_trigger becomes set,
            DMA issues writes with address from INTR_SRC_ADDR and write value from INTR_SRC_WR_VAL corresponding to each
            bit set in this register.
            '''
      swaccess: "rw"
      hwaccess: "hro"
      regwen: "CFG_REGWEN"
      fields: [
        { name: "source"
          desc: "Source N needs interrupt cleared"
          bits: "NumIntClearSources-1:0"
          resval: 0x0
        }
      ]
    }
    { multireg: {
        name: "INTR_SRC_ADDR"
        desc: "Destination address for interrupt source clearing write."
        count: "NumIntClearSources"
        cname: "ADDR"
        swaccess: "rw"
        hwaccess: "hro"
        regwen: "CFG_REGWEN"
        fields: [
          { name: "addr"
            desc: "Destination address for interrupt source clearing write."
            bits: "31:0"
            resval: 0x0
          }
        ]
      }
    }
    { skipto: "0x124" }
    { multireg: {
        name: "INTR_SRC_WR_VAL"
        desc: "Write value for interrupt clearing write."
        count: "NumIntClearSources"
        cname: "WRVAL"
        swaccess: "rw"
        hwaccess: "hro"
        regwen: "CFG_REGWEN"
        fields: [
          { name: "wr_val"
            desc: "Write value for interrupt clearing write."
            bits: "31:0"
            resval: 0x0
          }
        ]
      }
    }
    { name: "AES_CTRL"
      desc: "Inline AES-CTR/GCM parameter register. The cipher operation/mode live in CONTROL."
      swaccess: "rw"
      hwaccess: "hro"
      regwen: "CFG_REGWEN"
      fields: [
        { bits: "2:0"
          name: "key_len"
          resval: 0x4
          desc: '''
                AES key length, one-hot (aes_pkg::key_len_e). AES-128/192/256 supported.
                '''
          enum: [
            { value: "1", name: "AES_128", desc: "128-bit key." }
            { value: "2", name: "AES_192", desc: "192-bit key." }
            { value: "4", name: "AES_256", desc: "256-bit key (reset value)." }
          ]
        }
        { bits: "3"
          name: "sideload"
          resval: 0x0
          desc: '''
                Key source select (plain encoding, consistent with the rest of the config; shadow
                the register if FI protection is required).
                0 = use KEY_SHARE0/1; 1 = use the keymgr sideload key.
                '''
        }
        { bits: "7:5"
          name: "prng_reseed_rate"
          resval: 0x1
          desc: "Masking-PRNG reseed rate, one-hot (aes_pkg)."
          enum: [
            { value: "1", name: "PER_1",  desc: "Reseed after every block." }
            { value: "2", name: "PER_64", desc: "Reseed after 64 blocks." }
            { value: "4", name: "PER_8K", desc: "Reseed after 8k blocks." }
          ]
        }
        { bits: "11:8"
          name: "aad_blocks"
          resval: 0x0
          desc: "Number of 16-byte AAD blocks (from the AAD registers) for AES-GCM."
        }
      ]
    }
    { multireg: {
        name: "KEY_SHARE0"
        desc: '''
              Inline AES initial key, share 0. The effective key is KEY_SHARE0 ^ KEY_SHARE1.
              Write-only (never software-readable); ignored when AES_CTRL.sideload selects the
              keymgr key. Wiped by hardware after use.
              '''
        count: "8"
        cname: "KEY_SHARE0"
        swaccess: "wo"
        hwaccess: "hrw"
        regwen: "CFG_REGWEN"
        fields: [
          { name: "key", desc: "Key share 0 word.", bits: "31:0", resval: "0" }
        ]
      }
    }
    { multireg: {
        name: "KEY_SHARE1"
        desc: "Inline AES initial key, share 1. See KEY_SHARE0."
        count: "8"
        cname: "KEY_SHARE1"
        swaccess: "wo"
        hwaccess: "hrw"
        regwen: "CFG_REGWEN"
        fields: [
          { name: "key", desc: "Key share 1 word.", bits: "31:0", resval: "0" }
        ]
      }
    }
    { multireg: {
        name: "IV"
        desc: '''
              Inline AES-GCM/CTR initialization vector (nonce + counter), 128-bit.
              IV[3:1] is the 96-bit nonce; IV[0] (the counter word) is hardware-forced to the GCM
              J0 low value on a fresh operation. Wiped by hardware after use.
              '''
        count: "4"
        cname: "IV"
        swaccess: "rw"
        hwaccess: "hrw"
        regwen: "CFG_REGWEN"
        // HW may overwrite IV (J0-force / SEC_WIPE), so skip the write-readback value check in the
        // non-init CSR tests (the hw_reset init check still verifies the reset value).
        tags: ["excl:CsrNonInitTests:CsrExclWriteCheck"]
        fields: [
          { name: "iv", desc: "IV word.", bits: "31:0", resval: "0" }
        ]
      }
    }
    { multireg: {
        name: "AAD"
        desc: '''
              Inline AES-GCM additional authenticated data (from CSR). AES_CTRL.aad_blocks selects
              how many 16-byte blocks are valid. Write-only; wiped by hardware after use.
              '''
        count: "NumAadWords"
        cname: "AAD"
        swaccess: "wo"
        hwaccess: "hrw"
        regwen: "CFG_REGWEN"
        fields: [
          { name: "aad", desc: "AAD word.", bits: "31:0", resval: "0" }
        ]
      }
    }
    { multireg: {
        name: "TAG_IN"
        desc: '''
              Inline AES-GCM decrypt: the expected authentication tag, 128-bit. Write-only (the
              recomputed tag is never exposed); captured at start. Hardware compares internally and
              reports the result in STATUS.tag_failed. Wiped by hardware after use.
              '''
        count: "4"
        cname: "TAG_IN"
        swaccess: "wo"
        hwaccess: "hrw"
        regwen: "CFG_REGWEN"
        fields: [
          { name: "tag", desc: "Expected tag word.", bits: "31:0", resval: "0" }
        ]
      }
    }
    { multireg: {
        name: "TAG_OUT"
        desc: '''
              Inline AES-GCM encrypt: the computed authentication tag, 128-bit. Hardware-driven and
              read-only; valid when STATUS.tag_valid is set. Wiped by hardware after use.
              '''
        count: "4"
        cname: "TAG_OUT"
        swaccess: "ro"
        hwaccess: "hrw"
        hwext: "true"
        hwre: "true"
        // Hardware-driven (hwext), so the value is not RAL-predictable; skip the CSR value checks.
        tags: ["excl:CsrAllTests:CsrExclCheck"]
        fields: [
          { name: "tag", desc: "Computed tag word.", bits: "31:0", resval: "0" }
        ]
      }
    }
    { multireg: {
        name: "CLEAR_INTR_ASID"
        desc: "Encoded target port ID for each interrupt-clearing write. An enabled source with an unconfigured or invalid ASID raises asid_error without issuing that write."
        count: "NumIntClearSources"
        cname: "SOURCE"
        compact: "false"
        swaccess: "rw"
        hwaccess: "hro"
        regwen: "CFG_REGWEN"
        fields: [
          { name: "asid", desc: "Target ASID from the ADDR_SPACE_ID codebook.", bits: "7:0", resval: "0" }
        ]
      }
    }
  ]
}
